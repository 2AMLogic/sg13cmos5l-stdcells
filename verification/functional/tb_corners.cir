* Generated by verification/functional/gen_functional.py; do not edit.
* Issue #120: every timing arc of all 40 cells, one
* instance each, at the ratified characterization grid's worst point
* (input slew 2.5074 ns, output load 0.3 pF) -- see
* spec/decision-records/0005-timing-margin-spec-row.md.
* The 2.5074 ns slew is a 20-80% transition per the recorded
* Liberty's own thresholds, so the rail-to-rail ramp is 4.179 ns
* (slew / derate / span) -- the same stimulus klt characterize applies.
* Swept per corner by corners.request.json: process section,
* temperature, and the Vdd source. SIMULATED, never measured.
Vdd vdd 0 1.2
* Unitless 0 -> 1 -> 0 shape; Bin scales it to the corner's rail.
Vshape vshape 0 PWL(0 0 30.0n 0 34.179n 1 64.179n 1 68.358n 0 98.358n 0)
Bin vin 0 V = v(vdd)*v(vshape)
.include ../../design/netlists/s5l_a21o_1.spice
.include ../../design/netlists/s5l_a21o_2.spice
.include ../../design/netlists/s5l_a21oi_1.spice
.include ../../design/netlists/s5l_a21oi_2.spice
.include ../../design/netlists/s5l_a221oi_1.spice
.include ../../design/netlists/s5l_a22oi_1.spice
.include ../../design/netlists/s5l_and2_1.spice
.include ../../design/netlists/s5l_and2_2.spice
.include ../../design/netlists/s5l_and3_1.spice
.include ../../design/netlists/s5l_and3_2.spice
.include ../../design/netlists/s5l_and4_1.spice
.include ../../design/netlists/s5l_buf_1.spice
.include ../../design/netlists/s5l_buf_2.spice
.include ../../design/netlists/s5l_buf_4.spice
.include ../../design/netlists/s5l_inv_1.spice
.include ../../design/netlists/s5l_inv_2.spice
.include ../../design/netlists/s5l_inv_4.spice
.include ../../design/netlists/s5l_mux2_1.spice
.include ../../design/netlists/s5l_mux2_2.spice
.include ../../design/netlists/s5l_mux4_1.spice
.include ../../design/netlists/s5l_nand2_1.spice
.include ../../design/netlists/s5l_nand2_2.spice
.include ../../design/netlists/s5l_nand2b_1.spice
.include ../../design/netlists/s5l_nand3_1.spice
.include ../../design/netlists/s5l_nand3b_1.spice
.include ../../design/netlists/s5l_nand4_1.spice
.include ../../design/netlists/s5l_nor2_1.spice
.include ../../design/netlists/s5l_nor2_2.spice
.include ../../design/netlists/s5l_nor2b_1.spice
.include ../../design/netlists/s5l_nor3_1.spice
.include ../../design/netlists/s5l_nor3_2.spice
.include ../../design/netlists/s5l_nor4_1.spice
.include ../../design/netlists/s5l_o21ai_1.spice
.include ../../design/netlists/s5l_or2_1.spice
.include ../../design/netlists/s5l_or2_2.spice
.include ../../design/netlists/s5l_or3_1.spice
.include ../../design/netlists/s5l_or3_2.spice
.include ../../design/netlists/s5l_or4_1.spice
.include ../../design/netlists/s5l_xnor2_1.spice
.include ../../design/netlists/s5l_xor2_1.spice
* arc s5l_a21o_1 A1 -> X, holding A2=1 B1=0
X0 vin vdd 0 a0 vdd 0 s5l_a21o_1
C0 a0 0 0.3p
B0 n0 0 V = v(a0)/v(vdd)
* arc s5l_a21o_1 A2 -> X, holding A1=1 B1=0
X1 vdd vin 0 a1 vdd 0 s5l_a21o_1
C1 a1 0 0.3p
B1 n1 0 V = v(a1)/v(vdd)
* arc s5l_a21o_1 B1 -> X, holding A1=0 A2=0
X2 0 0 vin a2 vdd 0 s5l_a21o_1
C2 a2 0 0.3p
B2 n2 0 V = v(a2)/v(vdd)
* arc s5l_a21o_2 A1 -> X, holding A2=1 B1=0
X3 vin vdd 0 a3 vdd 0 s5l_a21o_2
C3 a3 0 0.3p
B3 n3 0 V = v(a3)/v(vdd)
* arc s5l_a21o_2 A2 -> X, holding A1=1 B1=0
X4 vdd vin 0 a4 vdd 0 s5l_a21o_2
C4 a4 0 0.3p
B4 n4 0 V = v(a4)/v(vdd)
* arc s5l_a21o_2 B1 -> X, holding A1=0 A2=0
X5 0 0 vin a5 vdd 0 s5l_a21o_2
C5 a5 0 0.3p
B5 n5 0 V = v(a5)/v(vdd)
* arc s5l_a21oi_1 A1 -> Y, holding A2=1 B1=0
X6 vin vdd 0 a6 vdd 0 s5l_a21oi_1
C6 a6 0 0.3p
B6 n6 0 V = v(a6)/v(vdd)
* arc s5l_a21oi_1 A2 -> Y, holding A1=1 B1=0
X7 vdd vin 0 a7 vdd 0 s5l_a21oi_1
C7 a7 0 0.3p
B7 n7 0 V = v(a7)/v(vdd)
* arc s5l_a21oi_1 B1 -> Y, holding A1=0 A2=0
X8 0 0 vin a8 vdd 0 s5l_a21oi_1
C8 a8 0 0.3p
B8 n8 0 V = v(a8)/v(vdd)
* arc s5l_a21oi_2 A1 -> Y, holding A2=1 B1=0
X9 vin vdd 0 a9 vdd 0 s5l_a21oi_2
C9 a9 0 0.3p
B9 n9 0 V = v(a9)/v(vdd)
* arc s5l_a21oi_2 A2 -> Y, holding A1=1 B1=0
X10 vdd vin 0 a10 vdd 0 s5l_a21oi_2
C10 a10 0 0.3p
B10 n10 0 V = v(a10)/v(vdd)
* arc s5l_a21oi_2 B1 -> Y, holding A1=0 A2=0
X11 0 0 vin a11 vdd 0 s5l_a21oi_2
C11 a11 0 0.3p
B11 n11 0 V = v(a11)/v(vdd)
* arc s5l_a22oi_1 A1 -> Y, holding A2=1 B1=0 B2=0
X12 vin vdd 0 0 a12 vdd 0 s5l_a22oi_1
C12 a12 0 0.3p
B12 n12 0 V = v(a12)/v(vdd)
* arc s5l_a22oi_1 A2 -> Y, holding A1=1 B1=0 B2=0
X13 vdd vin 0 0 a13 vdd 0 s5l_a22oi_1
C13 a13 0 0.3p
B13 n13 0 V = v(a13)/v(vdd)
* arc s5l_a22oi_1 B1 -> Y, holding A1=0 A2=0 B2=1
X14 0 0 vin vdd a14 vdd 0 s5l_a22oi_1
C14 a14 0 0.3p
B14 n14 0 V = v(a14)/v(vdd)
* arc s5l_a22oi_1 B2 -> Y, holding A1=0 A2=0 B1=1
X15 0 0 vdd vin a15 vdd 0 s5l_a22oi_1
C15 a15 0 0.3p
B15 n15 0 V = v(a15)/v(vdd)
* arc s5l_a221oi_1 A1 -> Y, holding A2=1 B1=0 B2=0 C1=0
X16 vin vdd 0 0 0 a16 vdd 0 s5l_a221oi_1
C16 a16 0 0.3p
B16 n16 0 V = v(a16)/v(vdd)
* arc s5l_a221oi_1 A2 -> Y, holding A1=1 B1=0 B2=0 C1=0
X17 vdd vin 0 0 0 a17 vdd 0 s5l_a221oi_1
C17 a17 0 0.3p
B17 n17 0 V = v(a17)/v(vdd)
* arc s5l_a221oi_1 B1 -> Y, holding A1=0 A2=0 B2=1 C1=0
X18 0 0 vin vdd 0 a18 vdd 0 s5l_a221oi_1
C18 a18 0 0.3p
B18 n18 0 V = v(a18)/v(vdd)
* arc s5l_a221oi_1 B2 -> Y, holding A1=0 A2=0 B1=1 C1=0
X19 0 0 vdd vin 0 a19 vdd 0 s5l_a221oi_1
C19 a19 0 0.3p
B19 n19 0 V = v(a19)/v(vdd)
* arc s5l_a221oi_1 C1 -> Y, holding A1=0 A2=0 B1=0 B2=0
X20 0 0 0 0 vin a20 vdd 0 s5l_a221oi_1
C20 a20 0 0.3p
B20 n20 0 V = v(a20)/v(vdd)
* arc s5l_and2_1 A -> X, holding B=1
X21 vin vdd a21 vdd 0 s5l_and2_1
C21 a21 0 0.3p
B21 n21 0 V = v(a21)/v(vdd)
* arc s5l_and2_1 B -> X, holding A=1
X22 vdd vin a22 vdd 0 s5l_and2_1
C22 a22 0 0.3p
B22 n22 0 V = v(a22)/v(vdd)
* arc s5l_and2_2 A -> X, holding B=1
X23 vin vdd a23 vdd 0 s5l_and2_2
C23 a23 0 0.3p
B23 n23 0 V = v(a23)/v(vdd)
* arc s5l_and2_2 B -> X, holding A=1
X24 vdd vin a24 vdd 0 s5l_and2_2
C24 a24 0 0.3p
B24 n24 0 V = v(a24)/v(vdd)
* arc s5l_and3_1 A -> X, holding B=1 C=1
X25 vin vdd vdd a25 vdd 0 s5l_and3_1
C25 a25 0 0.3p
B25 n25 0 V = v(a25)/v(vdd)
* arc s5l_and3_1 B -> X, holding A=1 C=1
X26 vdd vin vdd a26 vdd 0 s5l_and3_1
C26 a26 0 0.3p
B26 n26 0 V = v(a26)/v(vdd)
* arc s5l_and3_1 C -> X, holding A=1 B=1
X27 vdd vdd vin a27 vdd 0 s5l_and3_1
C27 a27 0 0.3p
B27 n27 0 V = v(a27)/v(vdd)
* arc s5l_and3_2 A -> X, holding B=1 C=1
X28 vin vdd vdd a28 vdd 0 s5l_and3_2
C28 a28 0 0.3p
B28 n28 0 V = v(a28)/v(vdd)
* arc s5l_and3_2 B -> X, holding A=1 C=1
X29 vdd vin vdd a29 vdd 0 s5l_and3_2
C29 a29 0 0.3p
B29 n29 0 V = v(a29)/v(vdd)
* arc s5l_and3_2 C -> X, holding A=1 B=1
X30 vdd vdd vin a30 vdd 0 s5l_and3_2
C30 a30 0 0.3p
B30 n30 0 V = v(a30)/v(vdd)
* arc s5l_and4_1 A -> X, holding B=1 C=1 D=1
X31 vin vdd vdd vdd a31 vdd 0 s5l_and4_1
C31 a31 0 0.3p
B31 n31 0 V = v(a31)/v(vdd)
* arc s5l_and4_1 B -> X, holding A=1 C=1 D=1
X32 vdd vin vdd vdd a32 vdd 0 s5l_and4_1
C32 a32 0 0.3p
B32 n32 0 V = v(a32)/v(vdd)
* arc s5l_and4_1 C -> X, holding A=1 B=1 D=1
X33 vdd vdd vin vdd a33 vdd 0 s5l_and4_1
C33 a33 0 0.3p
B33 n33 0 V = v(a33)/v(vdd)
* arc s5l_and4_1 D -> X, holding A=1 B=1 C=1
X34 vdd vdd vdd vin a34 vdd 0 s5l_and4_1
C34 a34 0 0.3p
B34 n34 0 V = v(a34)/v(vdd)
* arc s5l_buf_1 A -> X
X35 vin a35 vdd 0 s5l_buf_1
C35 a35 0 0.3p
B35 n35 0 V = v(a35)/v(vdd)
* arc s5l_buf_2 A -> X
X36 vin a36 vdd 0 s5l_buf_2
C36 a36 0 0.3p
B36 n36 0 V = v(a36)/v(vdd)
* arc s5l_buf_4 A -> X
X37 vin a37 vdd 0 s5l_buf_4
C37 a37 0 0.3p
B37 n37 0 V = v(a37)/v(vdd)
* arc s5l_inv_1 A -> Y
X38 vin a38 vdd 0 s5l_inv_1
C38 a38 0 0.3p
B38 n38 0 V = v(a38)/v(vdd)
* arc s5l_inv_2 A -> Y
X39 vin a39 vdd 0 s5l_inv_2
C39 a39 0 0.3p
B39 n39 0 V = v(a39)/v(vdd)
* arc s5l_inv_4 A -> Y
X40 vin a40 vdd 0 s5l_inv_4
C40 a40 0 0.3p
B40 n40 0 V = v(a40)/v(vdd)
* arc s5l_mux2_1 A0 -> X, holding A1=0 S=0
X41 vin 0 0 a41 vdd 0 s5l_mux2_1
C41 a41 0 0.3p
B41 n41 0 V = v(a41)/v(vdd)
* arc s5l_mux2_1 A1 -> X, holding A0=0 S=1
X42 0 vin vdd a42 vdd 0 s5l_mux2_1
C42 a42 0 0.3p
B42 n42 0 V = v(a42)/v(vdd)
* arc s5l_mux2_1 S -> X, holding A0=0 A1=1
X43 0 vdd vin a43 vdd 0 s5l_mux2_1
C43 a43 0 0.3p
B43 n43 0 V = v(a43)/v(vdd)
* arc s5l_mux2_2 A0 -> X, holding A1=0 S=0
X44 vin 0 0 a44 vdd 0 s5l_mux2_2
C44 a44 0 0.3p
B44 n44 0 V = v(a44)/v(vdd)
* arc s5l_mux2_2 A1 -> X, holding A0=0 S=1
X45 0 vin vdd a45 vdd 0 s5l_mux2_2
C45 a45 0 0.3p
B45 n45 0 V = v(a45)/v(vdd)
* arc s5l_mux2_2 S -> X, holding A0=0 A1=1
X46 0 vdd vin a46 vdd 0 s5l_mux2_2
C46 a46 0 0.3p
B46 n46 0 V = v(a46)/v(vdd)
* arc s5l_mux4_1 A0 -> X, holding A1=0 A2=0 A3=0 S0=0 S1=0
X47 vin 0 0 0 0 0 a47 vdd 0 s5l_mux4_1
C47 a47 0 0.3p
B47 n47 0 V = v(a47)/v(vdd)
* arc s5l_mux4_1 A1 -> X, holding A0=0 A2=0 A3=0 S0=1 S1=0
X48 0 vin 0 0 vdd 0 a48 vdd 0 s5l_mux4_1
C48 a48 0 0.3p
B48 n48 0 V = v(a48)/v(vdd)
* arc s5l_mux4_1 A2 -> X, holding A0=0 A1=0 A3=0 S0=0 S1=1
X49 0 0 vin 0 0 vdd a49 vdd 0 s5l_mux4_1
C49 a49 0 0.3p
B49 n49 0 V = v(a49)/v(vdd)
* arc s5l_mux4_1 A3 -> X, holding A0=0 A1=0 A2=0 S0=1 S1=1
X50 0 0 0 vin vdd vdd a50 vdd 0 s5l_mux4_1
C50 a50 0 0.3p
B50 n50 0 V = v(a50)/v(vdd)
* arc s5l_mux4_1 S0 -> X, holding A0=0 A1=0 A2=0 A3=1 S1=1
X51 0 0 0 vdd vin vdd a51 vdd 0 s5l_mux4_1
C51 a51 0 0.3p
B51 n51 0 V = v(a51)/v(vdd)
* arc s5l_mux4_1 S1 -> X, holding A0=0 A1=0 A2=0 A3=1 S0=1
X52 0 0 0 vdd vdd vin a52 vdd 0 s5l_mux4_1
C52 a52 0 0.3p
B52 n52 0 V = v(a52)/v(vdd)
* arc s5l_nand2_1 A -> Y, holding B=1
X53 vin vdd a53 vdd 0 s5l_nand2_1
C53 a53 0 0.3p
B53 n53 0 V = v(a53)/v(vdd)
* arc s5l_nand2_1 B -> Y, holding A=1
X54 vdd vin a54 vdd 0 s5l_nand2_1
C54 a54 0 0.3p
B54 n54 0 V = v(a54)/v(vdd)
* arc s5l_nand2_2 A -> Y, holding B=1
X55 vin vdd a55 vdd 0 s5l_nand2_2
C55 a55 0 0.3p
B55 n55 0 V = v(a55)/v(vdd)
* arc s5l_nand2_2 B -> Y, holding A=1
X56 vdd vin a56 vdd 0 s5l_nand2_2
C56 a56 0 0.3p
B56 n56 0 V = v(a56)/v(vdd)
* arc s5l_nand2b_1 A_N -> Y, holding B=1
X57 vin vdd a57 vdd 0 s5l_nand2b_1
C57 a57 0 0.3p
B57 n57 0 V = v(a57)/v(vdd)
* arc s5l_nand2b_1 B -> Y, holding A_N=0
X58 0 vin a58 vdd 0 s5l_nand2b_1
C58 a58 0 0.3p
B58 n58 0 V = v(a58)/v(vdd)
* arc s5l_nand3_1 A -> Y, holding B=1 C=1
X59 vin vdd vdd a59 vdd 0 s5l_nand3_1
C59 a59 0 0.3p
B59 n59 0 V = v(a59)/v(vdd)
* arc s5l_nand3_1 B -> Y, holding A=1 C=1
X60 vdd vin vdd a60 vdd 0 s5l_nand3_1
C60 a60 0 0.3p
B60 n60 0 V = v(a60)/v(vdd)
* arc s5l_nand3_1 C -> Y, holding A=1 B=1
X61 vdd vdd vin a61 vdd 0 s5l_nand3_1
C61 a61 0 0.3p
B61 n61 0 V = v(a61)/v(vdd)
* arc s5l_nand3b_1 A_N -> Y, holding B=1 C=1
X62 vin vdd vdd a62 vdd 0 s5l_nand3b_1
C62 a62 0 0.3p
B62 n62 0 V = v(a62)/v(vdd)
* arc s5l_nand3b_1 B -> Y, holding A_N=0 C=1
X63 0 vin vdd a63 vdd 0 s5l_nand3b_1
C63 a63 0 0.3p
B63 n63 0 V = v(a63)/v(vdd)
* arc s5l_nand3b_1 C -> Y, holding A_N=0 B=1
X64 0 vdd vin a64 vdd 0 s5l_nand3b_1
C64 a64 0 0.3p
B64 n64 0 V = v(a64)/v(vdd)
* arc s5l_nand4_1 A -> Y, holding B=1 C=1 D=1
X65 vin vdd vdd vdd a65 vdd 0 s5l_nand4_1
C65 a65 0 0.3p
B65 n65 0 V = v(a65)/v(vdd)
* arc s5l_nand4_1 B -> Y, holding A=1 C=1 D=1
X66 vdd vin vdd vdd a66 vdd 0 s5l_nand4_1
C66 a66 0 0.3p
B66 n66 0 V = v(a66)/v(vdd)
* arc s5l_nand4_1 C -> Y, holding A=1 B=1 D=1
X67 vdd vdd vin vdd a67 vdd 0 s5l_nand4_1
C67 a67 0 0.3p
B67 n67 0 V = v(a67)/v(vdd)
* arc s5l_nand4_1 D -> Y, holding A=1 B=1 C=1
X68 vdd vdd vdd vin a68 vdd 0 s5l_nand4_1
C68 a68 0 0.3p
B68 n68 0 V = v(a68)/v(vdd)
* arc s5l_nor2_1 A -> Y, holding B=0
X69 vin 0 a69 vdd 0 s5l_nor2_1
C69 a69 0 0.3p
B69 n69 0 V = v(a69)/v(vdd)
* arc s5l_nor2_1 B -> Y, holding A=0
X70 0 vin a70 vdd 0 s5l_nor2_1
C70 a70 0 0.3p
B70 n70 0 V = v(a70)/v(vdd)
* arc s5l_nor2_2 A -> Y, holding B=0
X71 vin 0 a71 vdd 0 s5l_nor2_2
C71 a71 0 0.3p
B71 n71 0 V = v(a71)/v(vdd)
* arc s5l_nor2_2 B -> Y, holding A=0
X72 0 vin a72 vdd 0 s5l_nor2_2
C72 a72 0 0.3p
B72 n72 0 V = v(a72)/v(vdd)
* arc s5l_nor2b_1 A -> Y, holding B_N=1
X73 vin vdd a73 vdd 0 s5l_nor2b_1
C73 a73 0 0.3p
B73 n73 0 V = v(a73)/v(vdd)
* arc s5l_nor2b_1 B_N -> Y, holding A=0
X74 0 vin a74 vdd 0 s5l_nor2b_1
C74 a74 0 0.3p
B74 n74 0 V = v(a74)/v(vdd)
* arc s5l_nor3_1 A -> Y, holding B=0 C=0
X75 vin 0 0 a75 vdd 0 s5l_nor3_1
C75 a75 0 0.3p
B75 n75 0 V = v(a75)/v(vdd)
* arc s5l_nor3_1 B -> Y, holding A=0 C=0
X76 0 vin 0 a76 vdd 0 s5l_nor3_1
C76 a76 0 0.3p
B76 n76 0 V = v(a76)/v(vdd)
* arc s5l_nor3_1 C -> Y, holding A=0 B=0
X77 0 0 vin a77 vdd 0 s5l_nor3_1
C77 a77 0 0.3p
B77 n77 0 V = v(a77)/v(vdd)
* arc s5l_nor3_2 A -> Y, holding B=0 C=0
X78 vin 0 0 a78 vdd 0 s5l_nor3_2
C78 a78 0 0.3p
B78 n78 0 V = v(a78)/v(vdd)
* arc s5l_nor3_2 B -> Y, holding A=0 C=0
X79 0 vin 0 a79 vdd 0 s5l_nor3_2
C79 a79 0 0.3p
B79 n79 0 V = v(a79)/v(vdd)
* arc s5l_nor3_2 C -> Y, holding A=0 B=0
X80 0 0 vin a80 vdd 0 s5l_nor3_2
C80 a80 0 0.3p
B80 n80 0 V = v(a80)/v(vdd)
* arc s5l_nor4_1 A -> Y, holding B=0 C=0 D=0
X81 vin 0 0 0 a81 vdd 0 s5l_nor4_1
C81 a81 0 0.3p
B81 n81 0 V = v(a81)/v(vdd)
* arc s5l_nor4_1 B -> Y, holding A=0 C=0 D=0
X82 0 vin 0 0 a82 vdd 0 s5l_nor4_1
C82 a82 0 0.3p
B82 n82 0 V = v(a82)/v(vdd)
* arc s5l_nor4_1 C -> Y, holding A=0 B=0 D=0
X83 0 0 vin 0 a83 vdd 0 s5l_nor4_1
C83 a83 0 0.3p
B83 n83 0 V = v(a83)/v(vdd)
* arc s5l_nor4_1 D -> Y, holding A=0 B=0 C=0
X84 0 0 0 vin a84 vdd 0 s5l_nor4_1
C84 a84 0 0.3p
B84 n84 0 V = v(a84)/v(vdd)
* arc s5l_o21ai_1 A1 -> Y, holding A2=0 B1=1
X85 vin 0 vdd a85 vdd 0 s5l_o21ai_1
C85 a85 0 0.3p
B85 n85 0 V = v(a85)/v(vdd)
* arc s5l_o21ai_1 A2 -> Y, holding A1=0 B1=1
X86 0 vin vdd a86 vdd 0 s5l_o21ai_1
C86 a86 0 0.3p
B86 n86 0 V = v(a86)/v(vdd)
* arc s5l_o21ai_1 B1 -> Y, holding A1=0 A2=1
X87 0 vdd vin a87 vdd 0 s5l_o21ai_1
C87 a87 0 0.3p
B87 n87 0 V = v(a87)/v(vdd)
* arc s5l_or2_1 A -> X, holding B=0
X88 vin 0 a88 vdd 0 s5l_or2_1
C88 a88 0 0.3p
B88 n88 0 V = v(a88)/v(vdd)
* arc s5l_or2_1 B -> X, holding A=0
X89 0 vin a89 vdd 0 s5l_or2_1
C89 a89 0 0.3p
B89 n89 0 V = v(a89)/v(vdd)
* arc s5l_or2_2 A -> X, holding B=0
X90 vin 0 a90 vdd 0 s5l_or2_2
C90 a90 0 0.3p
B90 n90 0 V = v(a90)/v(vdd)
* arc s5l_or2_2 B -> X, holding A=0
X91 0 vin a91 vdd 0 s5l_or2_2
C91 a91 0 0.3p
B91 n91 0 V = v(a91)/v(vdd)
* arc s5l_or3_1 A -> X, holding B=0 C=0
X92 vin 0 0 a92 vdd 0 s5l_or3_1
C92 a92 0 0.3p
B92 n92 0 V = v(a92)/v(vdd)
* arc s5l_or3_1 B -> X, holding A=0 C=0
X93 0 vin 0 a93 vdd 0 s5l_or3_1
C93 a93 0 0.3p
B93 n93 0 V = v(a93)/v(vdd)
* arc s5l_or3_1 C -> X, holding A=0 B=0
X94 0 0 vin a94 vdd 0 s5l_or3_1
C94 a94 0 0.3p
B94 n94 0 V = v(a94)/v(vdd)
* arc s5l_or3_2 A -> X, holding B=0 C=0
X95 vin 0 0 a95 vdd 0 s5l_or3_2
C95 a95 0 0.3p
B95 n95 0 V = v(a95)/v(vdd)
* arc s5l_or3_2 B -> X, holding A=0 C=0
X96 0 vin 0 a96 vdd 0 s5l_or3_2
C96 a96 0 0.3p
B96 n96 0 V = v(a96)/v(vdd)
* arc s5l_or3_2 C -> X, holding A=0 B=0
X97 0 0 vin a97 vdd 0 s5l_or3_2
C97 a97 0 0.3p
B97 n97 0 V = v(a97)/v(vdd)
* arc s5l_or4_1 A -> X, holding B=0 C=0 D=0
X98 vin 0 0 0 a98 vdd 0 s5l_or4_1
C98 a98 0 0.3p
B98 n98 0 V = v(a98)/v(vdd)
* arc s5l_or4_1 B -> X, holding A=0 C=0 D=0
X99 0 vin 0 0 a99 vdd 0 s5l_or4_1
C99 a99 0 0.3p
B99 n99 0 V = v(a99)/v(vdd)
* arc s5l_or4_1 C -> X, holding A=0 B=0 D=0
X100 0 0 vin 0 a100 vdd 0 s5l_or4_1
C100 a100 0 0.3p
B100 n100 0 V = v(a100)/v(vdd)
* arc s5l_or4_1 D -> X, holding A=0 B=0 C=0
X101 0 0 0 vin a101 vdd 0 s5l_or4_1
C101 a101 0 0.3p
B101 n101 0 V = v(a101)/v(vdd)
* arc s5l_xnor2_1 A -> Y, holding B=0
X102 vin 0 a102 vdd 0 s5l_xnor2_1
C102 a102 0 0.3p
B102 n102 0 V = v(a102)/v(vdd)
* arc s5l_xnor2_1 B -> Y, holding A=0
X103 0 vin a103 vdd 0 s5l_xnor2_1
C103 a103 0 0.3p
B103 n103 0 V = v(a103)/v(vdd)
* arc s5l_xor2_1 A -> X, holding B=0
X104 vin 0 a104 vdd 0 s5l_xor2_1
C104 a104 0 0.3p
B104 n104 0 V = v(a104)/v(vdd)
* arc s5l_xor2_1 B -> X, holding A=0
X105 0 vin a105 vdd 0 s5l_xor2_1
C105 a105 0 0.3p
B105 n105 0 V = v(a105)/v(vdd)
