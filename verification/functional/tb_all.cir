* Generated by verification/functional/gen_functional.py; do not edit.
* All cells, every input vector, TT. 1.2 V, window 4.0 ns. SIMULATED.
Vdd vdd 0 1.2
.include ../../design/netlists/s5l_a21o_1.spice
V0_a1 c0_a1 0 PWL(0 0.0 16.0n 0.0 16.1n 1.2 32.0n 1.2)
V0_a2 c0_a2 0 PWL(0 0.0 8.0n 0.0 8.1n 1.2 16.0n 1.2 16.1n 0.0 24.0n 0.0 24.1n 1.2 32.0n 1.2)
V0_b1 c0_b1 0 PWL(0 0.0 4.0n 0.0 4.1n 1.2 8.0n 1.2 8.1n 0.0 12.0n 0.0 12.1n 1.2 16.0n 1.2 16.1n 0.0 20.0n 0.0 20.1n 1.2 24.0n 1.2 24.1n 0.0 28.0n 0.0 28.1n 1.2 32.0n 1.2)
X0 c0_a1 c0_a2 c0_b1 c0_x vdd 0 s5l_a21o_1
C0_x c0_x 0 10f
.include ../../design/netlists/s5l_a21o_2.spice
V1_a1 c1_a1 0 PWL(0 0.0 16.0n 0.0 16.1n 1.2 32.0n 1.2)
V1_a2 c1_a2 0 PWL(0 0.0 8.0n 0.0 8.1n 1.2 16.0n 1.2 16.1n 0.0 24.0n 0.0 24.1n 1.2 32.0n 1.2)
V1_b1 c1_b1 0 PWL(0 0.0 4.0n 0.0 4.1n 1.2 8.0n 1.2 8.1n 0.0 12.0n 0.0 12.1n 1.2 16.0n 1.2 16.1n 0.0 20.0n 0.0 20.1n 1.2 24.0n 1.2 24.1n 0.0 28.0n 0.0 28.1n 1.2 32.0n 1.2)
X1 c1_a1 c1_a2 c1_b1 c1_x vdd 0 s5l_a21o_2
C1_x c1_x 0 10f
.include ../../design/netlists/s5l_a21oi_1.spice
V2_a1 c2_a1 0 PWL(0 0.0 16.0n 0.0 16.1n 1.2 32.0n 1.2)
V2_a2 c2_a2 0 PWL(0 0.0 8.0n 0.0 8.1n 1.2 16.0n 1.2 16.1n 0.0 24.0n 0.0 24.1n 1.2 32.0n 1.2)
V2_b1 c2_b1 0 PWL(0 0.0 4.0n 0.0 4.1n 1.2 8.0n 1.2 8.1n 0.0 12.0n 0.0 12.1n 1.2 16.0n 1.2 16.1n 0.0 20.0n 0.0 20.1n 1.2 24.0n 1.2 24.1n 0.0 28.0n 0.0 28.1n 1.2 32.0n 1.2)
X2 c2_a1 c2_a2 c2_b1 c2_y vdd 0 s5l_a21oi_1
C2_y c2_y 0 10f
.include ../../design/netlists/s5l_a21oi_2.spice
V3_a1 c3_a1 0 PWL(0 0.0 16.0n 0.0 16.1n 1.2 32.0n 1.2)
V3_a2 c3_a2 0 PWL(0 0.0 8.0n 0.0 8.1n 1.2 16.0n 1.2 16.1n 0.0 24.0n 0.0 24.1n 1.2 32.0n 1.2)
V3_b1 c3_b1 0 PWL(0 0.0 4.0n 0.0 4.1n 1.2 8.0n 1.2 8.1n 0.0 12.0n 0.0 12.1n 1.2 16.0n 1.2 16.1n 0.0 20.0n 0.0 20.1n 1.2 24.0n 1.2 24.1n 0.0 28.0n 0.0 28.1n 1.2 32.0n 1.2)
X3 c3_a1 c3_a2 c3_b1 c3_y vdd 0 s5l_a21oi_2
C3_y c3_y 0 10f
.include ../../design/netlists/s5l_a22oi_1.spice
V4_a1 c4_a1 0 PWL(0 0.0 32.0n 0.0 32.1n 1.2 64.0n 1.2)
V4_a2 c4_a2 0 PWL(0 0.0 16.0n 0.0 16.1n 1.2 32.0n 1.2 32.1n 0.0 48.0n 0.0 48.1n 1.2 64.0n 1.2)
V4_b1 c4_b1 0 PWL(0 0.0 8.0n 0.0 8.1n 1.2 16.0n 1.2 16.1n 0.0 24.0n 0.0 24.1n 1.2 32.0n 1.2 32.1n 0.0 40.0n 0.0 40.1n 1.2 48.0n 1.2 48.1n 0.0 56.0n 0.0 56.1n 1.2 64.0n 1.2)
V4_b2 c4_b2 0 PWL(0 0.0 4.0n 0.0 4.1n 1.2 8.0n 1.2 8.1n 0.0 12.0n 0.0 12.1n 1.2 16.0n 1.2 16.1n 0.0 20.0n 0.0 20.1n 1.2 24.0n 1.2 24.1n 0.0 28.0n 0.0 28.1n 1.2 32.0n 1.2 32.1n 0.0 36.0n 0.0 36.1n 1.2 40.0n 1.2 40.1n 0.0 44.0n 0.0 44.1n 1.2 48.0n 1.2 48.1n 0.0 52.0n 0.0 52.1n 1.2 56.0n 1.2 56.1n 0.0 60.0n 0.0 60.1n 1.2 64.0n 1.2)
X4 c4_a1 c4_a2 c4_b1 c4_b2 c4_y vdd 0 s5l_a22oi_1
C4_y c4_y 0 10f
.include ../../design/netlists/s5l_a221oi_1.spice
V5_a1 c5_a1 0 PWL(0 0.0 64.0n 0.0 64.1n 1.2 128.0n 1.2)
V5_a2 c5_a2 0 PWL(0 0.0 32.0n 0.0 32.1n 1.2 64.0n 1.2 64.1n 0.0 96.0n 0.0 96.1n 1.2 128.0n 1.2)
V5_b1 c5_b1 0 PWL(0 0.0 16.0n 0.0 16.1n 1.2 32.0n 1.2 32.1n 0.0 48.0n 0.0 48.1n 1.2 64.0n 1.2 64.1n 0.0 80.0n 0.0 80.1n 1.2 96.0n 1.2 96.1n 0.0 112.0n 0.0 112.1n 1.2 128.0n 1.2)
V5_b2 c5_b2 0 PWL(0 0.0 8.0n 0.0 8.1n 1.2 16.0n 1.2 16.1n 0.0 24.0n 0.0 24.1n 1.2 32.0n 1.2 32.1n 0.0 40.0n 0.0 40.1n 1.2 48.0n 1.2 48.1n 0.0 56.0n 0.0 56.1n 1.2 64.0n 1.2 64.1n 0.0 72.0n 0.0 72.1n 1.2 80.0n 1.2 80.1n 0.0 88.0n 0.0 88.1n 1.2 96.0n 1.2 96.1n 0.0 104.0n 0.0 104.1n 1.2 112.0n 1.2 112.1n 0.0 120.0n 0.0 120.1n 1.2 128.0n 1.2)
V5_c1 c5_c1 0 PWL(0 0.0 4.0n 0.0 4.1n 1.2 8.0n 1.2 8.1n 0.0 12.0n 0.0 12.1n 1.2 16.0n 1.2 16.1n 0.0 20.0n 0.0 20.1n 1.2 24.0n 1.2 24.1n 0.0 28.0n 0.0 28.1n 1.2 32.0n 1.2 32.1n 0.0 36.0n 0.0 36.1n 1.2 40.0n 1.2 40.1n 0.0 44.0n 0.0 44.1n 1.2 48.0n 1.2 48.1n 0.0 52.0n 0.0 52.1n 1.2 56.0n 1.2 56.1n 0.0 60.0n 0.0 60.1n 1.2 64.0n 1.2 64.1n 0.0 68.0n 0.0 68.1n 1.2 72.0n 1.2 72.1n 0.0 76.0n 0.0 76.1n 1.2 80.0n 1.2 80.1n 0.0 84.0n 0.0 84.1n 1.2 88.0n 1.2 88.1n 0.0 92.0n 0.0 92.1n 1.2 96.0n 1.2 96.1n 0.0 100.0n 0.0 100.1n 1.2 104.0n 1.2 104.1n 0.0 108.0n 0.0 108.1n 1.2 112.0n 1.2 112.1n 0.0 116.0n 0.0 116.1n 1.2 120.0n 1.2 120.1n 0.0 124.0n 0.0 124.1n 1.2 128.0n 1.2)
X5 c5_a1 c5_a2 c5_b1 c5_b2 c5_c1 c5_y vdd 0 s5l_a221oi_1
C5_y c5_y 0 10f
.include ../../design/netlists/s5l_and2_1.spice
V6_a c6_a 0 PWL(0 0.0 8.0n 0.0 8.1n 1.2 16.0n 1.2)
V6_b c6_b 0 PWL(0 0.0 4.0n 0.0 4.1n 1.2 8.0n 1.2 8.1n 0.0 12.0n 0.0 12.1n 1.2 16.0n 1.2)
X6 c6_a c6_b c6_x vdd 0 s5l_and2_1
C6_x c6_x 0 10f
.include ../../design/netlists/s5l_and2_2.spice
V7_a c7_a 0 PWL(0 0.0 8.0n 0.0 8.1n 1.2 16.0n 1.2)
V7_b c7_b 0 PWL(0 0.0 4.0n 0.0 4.1n 1.2 8.0n 1.2 8.1n 0.0 12.0n 0.0 12.1n 1.2 16.0n 1.2)
X7 c7_a c7_b c7_x vdd 0 s5l_and2_2
C7_x c7_x 0 10f
.include ../../design/netlists/s5l_and3_1.spice
V8_a c8_a 0 PWL(0 0.0 16.0n 0.0 16.1n 1.2 32.0n 1.2)
V8_b c8_b 0 PWL(0 0.0 8.0n 0.0 8.1n 1.2 16.0n 1.2 16.1n 0.0 24.0n 0.0 24.1n 1.2 32.0n 1.2)
V8_c c8_c 0 PWL(0 0.0 4.0n 0.0 4.1n 1.2 8.0n 1.2 8.1n 0.0 12.0n 0.0 12.1n 1.2 16.0n 1.2 16.1n 0.0 20.0n 0.0 20.1n 1.2 24.0n 1.2 24.1n 0.0 28.0n 0.0 28.1n 1.2 32.0n 1.2)
X8 c8_a c8_b c8_c c8_x vdd 0 s5l_and3_1
C8_x c8_x 0 10f
.include ../../design/netlists/s5l_and3_2.spice
V9_a c9_a 0 PWL(0 0.0 16.0n 0.0 16.1n 1.2 32.0n 1.2)
V9_b c9_b 0 PWL(0 0.0 8.0n 0.0 8.1n 1.2 16.0n 1.2 16.1n 0.0 24.0n 0.0 24.1n 1.2 32.0n 1.2)
V9_c c9_c 0 PWL(0 0.0 4.0n 0.0 4.1n 1.2 8.0n 1.2 8.1n 0.0 12.0n 0.0 12.1n 1.2 16.0n 1.2 16.1n 0.0 20.0n 0.0 20.1n 1.2 24.0n 1.2 24.1n 0.0 28.0n 0.0 28.1n 1.2 32.0n 1.2)
X9 c9_a c9_b c9_c c9_x vdd 0 s5l_and3_2
C9_x c9_x 0 10f
.include ../../design/netlists/s5l_and4_1.spice
V10_a c10_a 0 PWL(0 0.0 32.0n 0.0 32.1n 1.2 64.0n 1.2)
V10_b c10_b 0 PWL(0 0.0 16.0n 0.0 16.1n 1.2 32.0n 1.2 32.1n 0.0 48.0n 0.0 48.1n 1.2 64.0n 1.2)
V10_c c10_c 0 PWL(0 0.0 8.0n 0.0 8.1n 1.2 16.0n 1.2 16.1n 0.0 24.0n 0.0 24.1n 1.2 32.0n 1.2 32.1n 0.0 40.0n 0.0 40.1n 1.2 48.0n 1.2 48.1n 0.0 56.0n 0.0 56.1n 1.2 64.0n 1.2)
V10_d c10_d 0 PWL(0 0.0 4.0n 0.0 4.1n 1.2 8.0n 1.2 8.1n 0.0 12.0n 0.0 12.1n 1.2 16.0n 1.2 16.1n 0.0 20.0n 0.0 20.1n 1.2 24.0n 1.2 24.1n 0.0 28.0n 0.0 28.1n 1.2 32.0n 1.2 32.1n 0.0 36.0n 0.0 36.1n 1.2 40.0n 1.2 40.1n 0.0 44.0n 0.0 44.1n 1.2 48.0n 1.2 48.1n 0.0 52.0n 0.0 52.1n 1.2 56.0n 1.2 56.1n 0.0 60.0n 0.0 60.1n 1.2 64.0n 1.2)
X10 c10_a c10_b c10_c c10_d c10_x vdd 0 s5l_and4_1
C10_x c10_x 0 10f
.include ../../design/netlists/s5l_buf_1.spice
V11_a c11_a 0 PWL(0 0.0 4.0n 0.0 4.1n 1.2 8.0n 1.2)
X11 c11_a c11_x vdd 0 s5l_buf_1
C11_x c11_x 0 10f
.include ../../design/netlists/s5l_buf_2.spice
V12_a c12_a 0 PWL(0 0.0 4.0n 0.0 4.1n 1.2 8.0n 1.2)
X12 c12_a c12_x vdd 0 s5l_buf_2
C12_x c12_x 0 10f
.include ../../design/netlists/s5l_buf_4.spice
V13_a c13_a 0 PWL(0 0.0 4.0n 0.0 4.1n 1.2 8.0n 1.2)
X13 c13_a c13_x vdd 0 s5l_buf_4
C13_x c13_x 0 10f
.include ../../design/netlists/s5l_inv_1.spice
V14_a c14_a 0 PWL(0 0.0 4.0n 0.0 4.1n 1.2 8.0n 1.2)
X14 c14_a c14_y vdd 0 s5l_inv_1
C14_y c14_y 0 10f
.include ../../design/netlists/s5l_inv_2.spice
V15_a c15_a 0 PWL(0 0.0 4.0n 0.0 4.1n 1.2 8.0n 1.2)
X15 c15_a c15_y vdd 0 s5l_inv_2
C15_y c15_y 0 10f
.include ../../design/netlists/s5l_inv_4.spice
V16_a c16_a 0 PWL(0 0.0 4.0n 0.0 4.1n 1.2 8.0n 1.2)
X16 c16_a c16_y vdd 0 s5l_inv_4
C16_y c16_y 0 10f
.include ../../design/netlists/s5l_mux2_1.spice
V17_a0 c17_a0 0 PWL(0 0.0 16.0n 0.0 16.1n 1.2 32.0n 1.2)
V17_a1 c17_a1 0 PWL(0 0.0 8.0n 0.0 8.1n 1.2 16.0n 1.2 16.1n 0.0 24.0n 0.0 24.1n 1.2 32.0n 1.2)
V17_s c17_s 0 PWL(0 0.0 4.0n 0.0 4.1n 1.2 8.0n 1.2 8.1n 0.0 12.0n 0.0 12.1n 1.2 16.0n 1.2 16.1n 0.0 20.0n 0.0 20.1n 1.2 24.0n 1.2 24.1n 0.0 28.0n 0.0 28.1n 1.2 32.0n 1.2)
X17 c17_a0 c17_a1 c17_s c17_x vdd 0 s5l_mux2_1
C17_x c17_x 0 10f
.include ../../design/netlists/s5l_mux2_2.spice
V18_a0 c18_a0 0 PWL(0 0.0 16.0n 0.0 16.1n 1.2 32.0n 1.2)
V18_a1 c18_a1 0 PWL(0 0.0 8.0n 0.0 8.1n 1.2 16.0n 1.2 16.1n 0.0 24.0n 0.0 24.1n 1.2 32.0n 1.2)
V18_s c18_s 0 PWL(0 0.0 4.0n 0.0 4.1n 1.2 8.0n 1.2 8.1n 0.0 12.0n 0.0 12.1n 1.2 16.0n 1.2 16.1n 0.0 20.0n 0.0 20.1n 1.2 24.0n 1.2 24.1n 0.0 28.0n 0.0 28.1n 1.2 32.0n 1.2)
X18 c18_a0 c18_a1 c18_s c18_x vdd 0 s5l_mux2_2
C18_x c18_x 0 10f
.include ../../design/netlists/s5l_mux4_1.spice
V19_a0 c19_a0 0 PWL(0 0.0 128.0n 0.0 128.1n 1.2 256.0n 1.2)
V19_a1 c19_a1 0 PWL(0 0.0 64.0n 0.0 64.1n 1.2 128.0n 1.2 128.1n 0.0 192.0n 0.0 192.1n 1.2 256.0n 1.2)
V19_a2 c19_a2 0 PWL(0 0.0 32.0n 0.0 32.1n 1.2 64.0n 1.2 64.1n 0.0 96.0n 0.0 96.1n 1.2 128.0n 1.2 128.1n 0.0 160.0n 0.0 160.1n 1.2 192.0n 1.2 192.1n 0.0 224.0n 0.0 224.1n 1.2 256.0n 1.2)
V19_a3 c19_a3 0 PWL(0 0.0 16.0n 0.0 16.1n 1.2 32.0n 1.2 32.1n 0.0 48.0n 0.0 48.1n 1.2 64.0n 1.2 64.1n 0.0 80.0n 0.0 80.1n 1.2 96.0n 1.2 96.1n 0.0 112.0n 0.0 112.1n 1.2 128.0n 1.2 128.1n 0.0 144.0n 0.0 144.1n 1.2 160.0n 1.2 160.1n 0.0 176.0n 0.0 176.1n 1.2 192.0n 1.2 192.1n 0.0 208.0n 0.0 208.1n 1.2 224.0n 1.2 224.1n 0.0 240.0n 0.0 240.1n 1.2 256.0n 1.2)
V19_s0 c19_s0 0 PWL(0 0.0 8.0n 0.0 8.1n 1.2 16.0n 1.2 16.1n 0.0 24.0n 0.0 24.1n 1.2 32.0n 1.2 32.1n 0.0 40.0n 0.0 40.1n 1.2 48.0n 1.2 48.1n 0.0 56.0n 0.0 56.1n 1.2 64.0n 1.2 64.1n 0.0 72.0n 0.0 72.1n 1.2 80.0n 1.2 80.1n 0.0 88.0n 0.0 88.1n 1.2 96.0n 1.2 96.1n 0.0 104.0n 0.0 104.1n 1.2 112.0n 1.2 112.1n 0.0 120.0n 0.0 120.1n 1.2 128.0n 1.2 128.1n 0.0 136.0n 0.0 136.1n 1.2 144.0n 1.2 144.1n 0.0 152.0n 0.0 152.1n 1.2 160.0n 1.2 160.1n 0.0 168.0n 0.0 168.1n 1.2 176.0n 1.2 176.1n 0.0 184.0n 0.0 184.1n 1.2 192.0n 1.2 192.1n 0.0 200.0n 0.0 200.1n 1.2 208.0n 1.2 208.1n 0.0 216.0n 0.0 216.1n 1.2 224.0n 1.2 224.1n 0.0 232.0n 0.0 232.1n 1.2 240.0n 1.2 240.1n 0.0 248.0n 0.0 248.1n 1.2 256.0n 1.2)
V19_s1 c19_s1 0 PWL(0 0.0 4.0n 0.0 4.1n 1.2 8.0n 1.2 8.1n 0.0 12.0n 0.0 12.1n 1.2 16.0n 1.2 16.1n 0.0 20.0n 0.0 20.1n 1.2 24.0n 1.2 24.1n 0.0 28.0n 0.0 28.1n 1.2 32.0n 1.2 32.1n 0.0 36.0n 0.0 36.1n 1.2 40.0n 1.2 40.1n 0.0 44.0n 0.0 44.1n 1.2 48.0n 1.2 48.1n 0.0 52.0n 0.0 52.1n 1.2 56.0n 1.2 56.1n 0.0 60.0n 0.0 60.1n 1.2 64.0n 1.2 64.1n 0.0 68.0n 0.0 68.1n 1.2 72.0n 1.2 72.1n 0.0 76.0n 0.0 76.1n 1.2 80.0n 1.2 80.1n 0.0 84.0n 0.0 84.1n 1.2 88.0n 1.2 88.1n 0.0 92.0n 0.0 92.1n 1.2 96.0n 1.2 96.1n 0.0 100.0n 0.0 100.1n 1.2 104.0n 1.2 104.1n 0.0 108.0n 0.0 108.1n 1.2 112.0n 1.2 112.1n 0.0 116.0n 0.0 116.1n 1.2 120.0n 1.2 120.1n 0.0 124.0n 0.0 124.1n 1.2 128.0n 1.2 128.1n 0.0 132.0n 0.0 132.1n 1.2 136.0n 1.2 136.1n 0.0 140.0n 0.0 140.1n 1.2 144.0n 1.2 144.1n 0.0 148.0n 0.0 148.1n 1.2 152.0n 1.2 152.1n 0.0 156.0n 0.0 156.1n 1.2 160.0n 1.2 160.1n 0.0 164.0n 0.0 164.1n 1.2 168.0n 1.2 168.1n 0.0 172.0n 0.0 172.1n 1.2 176.0n 1.2 176.1n 0.0 180.0n 0.0 180.1n 1.2 184.0n 1.2 184.1n 0.0 188.0n 0.0 188.1n 1.2 192.0n 1.2 192.1n 0.0 196.0n 0.0 196.1n 1.2 200.0n 1.2 200.1n 0.0 204.0n 0.0 204.1n 1.2 208.0n 1.2 208.1n 0.0 212.0n 0.0 212.1n 1.2 216.0n 1.2 216.1n 0.0 220.0n 0.0 220.1n 1.2 224.0n 1.2 224.1n 0.0 228.0n 0.0 228.1n 1.2 232.0n 1.2 232.1n 0.0 236.0n 0.0 236.1n 1.2 240.0n 1.2 240.1n 0.0 244.0n 0.0 244.1n 1.2 248.0n 1.2 248.1n 0.0 252.0n 0.0 252.1n 1.2 256.0n 1.2)
X19 c19_a0 c19_a1 c19_a2 c19_a3 c19_s0 c19_s1 c19_x vdd 0 s5l_mux4_1
C19_x c19_x 0 10f
.include ../../design/netlists/s5l_nand2_1.spice
V20_a c20_a 0 PWL(0 0.0 8.0n 0.0 8.1n 1.2 16.0n 1.2)
V20_b c20_b 0 PWL(0 0.0 4.0n 0.0 4.1n 1.2 8.0n 1.2 8.1n 0.0 12.0n 0.0 12.1n 1.2 16.0n 1.2)
X20 c20_a c20_b c20_y vdd 0 s5l_nand2_1
C20_y c20_y 0 10f
.include ../../design/netlists/s5l_nand2_2.spice
V21_a c21_a 0 PWL(0 0.0 8.0n 0.0 8.1n 1.2 16.0n 1.2)
V21_b c21_b 0 PWL(0 0.0 4.0n 0.0 4.1n 1.2 8.0n 1.2 8.1n 0.0 12.0n 0.0 12.1n 1.2 16.0n 1.2)
X21 c21_a c21_b c21_y vdd 0 s5l_nand2_2
C21_y c21_y 0 10f
.include ../../design/netlists/s5l_nand2b_1.spice
V22_a_n c22_a_n 0 PWL(0 0.0 8.0n 0.0 8.1n 1.2 16.0n 1.2)
V22_b c22_b 0 PWL(0 0.0 4.0n 0.0 4.1n 1.2 8.0n 1.2 8.1n 0.0 12.0n 0.0 12.1n 1.2 16.0n 1.2)
X22 c22_a_n c22_b c22_y vdd 0 s5l_nand2b_1
C22_y c22_y 0 10f
.include ../../design/netlists/s5l_nand3_1.spice
V23_a c23_a 0 PWL(0 0.0 16.0n 0.0 16.1n 1.2 32.0n 1.2)
V23_b c23_b 0 PWL(0 0.0 8.0n 0.0 8.1n 1.2 16.0n 1.2 16.1n 0.0 24.0n 0.0 24.1n 1.2 32.0n 1.2)
V23_c c23_c 0 PWL(0 0.0 4.0n 0.0 4.1n 1.2 8.0n 1.2 8.1n 0.0 12.0n 0.0 12.1n 1.2 16.0n 1.2 16.1n 0.0 20.0n 0.0 20.1n 1.2 24.0n 1.2 24.1n 0.0 28.0n 0.0 28.1n 1.2 32.0n 1.2)
X23 c23_a c23_b c23_c c23_y vdd 0 s5l_nand3_1
C23_y c23_y 0 10f
.include ../../design/netlists/s5l_nand3b_1.spice
V24_a_n c24_a_n 0 PWL(0 0.0 16.0n 0.0 16.1n 1.2 32.0n 1.2)
V24_b c24_b 0 PWL(0 0.0 8.0n 0.0 8.1n 1.2 16.0n 1.2 16.1n 0.0 24.0n 0.0 24.1n 1.2 32.0n 1.2)
V24_c c24_c 0 PWL(0 0.0 4.0n 0.0 4.1n 1.2 8.0n 1.2 8.1n 0.0 12.0n 0.0 12.1n 1.2 16.0n 1.2 16.1n 0.0 20.0n 0.0 20.1n 1.2 24.0n 1.2 24.1n 0.0 28.0n 0.0 28.1n 1.2 32.0n 1.2)
X24 c24_a_n c24_b c24_c c24_y vdd 0 s5l_nand3b_1
C24_y c24_y 0 10f
.include ../../design/netlists/s5l_nand4_1.spice
V25_a c25_a 0 PWL(0 0.0 32.0n 0.0 32.1n 1.2 64.0n 1.2)
V25_b c25_b 0 PWL(0 0.0 16.0n 0.0 16.1n 1.2 32.0n 1.2 32.1n 0.0 48.0n 0.0 48.1n 1.2 64.0n 1.2)
V25_c c25_c 0 PWL(0 0.0 8.0n 0.0 8.1n 1.2 16.0n 1.2 16.1n 0.0 24.0n 0.0 24.1n 1.2 32.0n 1.2 32.1n 0.0 40.0n 0.0 40.1n 1.2 48.0n 1.2 48.1n 0.0 56.0n 0.0 56.1n 1.2 64.0n 1.2)
V25_d c25_d 0 PWL(0 0.0 4.0n 0.0 4.1n 1.2 8.0n 1.2 8.1n 0.0 12.0n 0.0 12.1n 1.2 16.0n 1.2 16.1n 0.0 20.0n 0.0 20.1n 1.2 24.0n 1.2 24.1n 0.0 28.0n 0.0 28.1n 1.2 32.0n 1.2 32.1n 0.0 36.0n 0.0 36.1n 1.2 40.0n 1.2 40.1n 0.0 44.0n 0.0 44.1n 1.2 48.0n 1.2 48.1n 0.0 52.0n 0.0 52.1n 1.2 56.0n 1.2 56.1n 0.0 60.0n 0.0 60.1n 1.2 64.0n 1.2)
X25 c25_a c25_b c25_c c25_d c25_y vdd 0 s5l_nand4_1
C25_y c25_y 0 10f
.include ../../design/netlists/s5l_nor2_1.spice
V26_a c26_a 0 PWL(0 0.0 8.0n 0.0 8.1n 1.2 16.0n 1.2)
V26_b c26_b 0 PWL(0 0.0 4.0n 0.0 4.1n 1.2 8.0n 1.2 8.1n 0.0 12.0n 0.0 12.1n 1.2 16.0n 1.2)
X26 c26_a c26_b c26_y vdd 0 s5l_nor2_1
C26_y c26_y 0 10f
.include ../../design/netlists/s5l_nor2_2.spice
V27_a c27_a 0 PWL(0 0.0 8.0n 0.0 8.1n 1.2 16.0n 1.2)
V27_b c27_b 0 PWL(0 0.0 4.0n 0.0 4.1n 1.2 8.0n 1.2 8.1n 0.0 12.0n 0.0 12.1n 1.2 16.0n 1.2)
X27 c27_a c27_b c27_y vdd 0 s5l_nor2_2
C27_y c27_y 0 10f
.include ../../design/netlists/s5l_nor2b_1.spice
V28_a c28_a 0 PWL(0 0.0 8.0n 0.0 8.1n 1.2 16.0n 1.2)
V28_b_n c28_b_n 0 PWL(0 0.0 4.0n 0.0 4.1n 1.2 8.0n 1.2 8.1n 0.0 12.0n 0.0 12.1n 1.2 16.0n 1.2)
X28 c28_a c28_b_n c28_y vdd 0 s5l_nor2b_1
C28_y c28_y 0 10f
.include ../../design/netlists/s5l_nor3_1.spice
V29_a c29_a 0 PWL(0 0.0 16.0n 0.0 16.1n 1.2 32.0n 1.2)
V29_b c29_b 0 PWL(0 0.0 8.0n 0.0 8.1n 1.2 16.0n 1.2 16.1n 0.0 24.0n 0.0 24.1n 1.2 32.0n 1.2)
V29_c c29_c 0 PWL(0 0.0 4.0n 0.0 4.1n 1.2 8.0n 1.2 8.1n 0.0 12.0n 0.0 12.1n 1.2 16.0n 1.2 16.1n 0.0 20.0n 0.0 20.1n 1.2 24.0n 1.2 24.1n 0.0 28.0n 0.0 28.1n 1.2 32.0n 1.2)
X29 c29_a c29_b c29_c c29_y vdd 0 s5l_nor3_1
C29_y c29_y 0 10f
.include ../../design/netlists/s5l_nor3_2.spice
V30_a c30_a 0 PWL(0 0.0 16.0n 0.0 16.1n 1.2 32.0n 1.2)
V30_b c30_b 0 PWL(0 0.0 8.0n 0.0 8.1n 1.2 16.0n 1.2 16.1n 0.0 24.0n 0.0 24.1n 1.2 32.0n 1.2)
V30_c c30_c 0 PWL(0 0.0 4.0n 0.0 4.1n 1.2 8.0n 1.2 8.1n 0.0 12.0n 0.0 12.1n 1.2 16.0n 1.2 16.1n 0.0 20.0n 0.0 20.1n 1.2 24.0n 1.2 24.1n 0.0 28.0n 0.0 28.1n 1.2 32.0n 1.2)
X30 c30_a c30_b c30_c c30_y vdd 0 s5l_nor3_2
C30_y c30_y 0 10f
.include ../../design/netlists/s5l_nor4_1.spice
V31_a c31_a 0 PWL(0 0.0 32.0n 0.0 32.1n 1.2 64.0n 1.2)
V31_b c31_b 0 PWL(0 0.0 16.0n 0.0 16.1n 1.2 32.0n 1.2 32.1n 0.0 48.0n 0.0 48.1n 1.2 64.0n 1.2)
V31_c c31_c 0 PWL(0 0.0 8.0n 0.0 8.1n 1.2 16.0n 1.2 16.1n 0.0 24.0n 0.0 24.1n 1.2 32.0n 1.2 32.1n 0.0 40.0n 0.0 40.1n 1.2 48.0n 1.2 48.1n 0.0 56.0n 0.0 56.1n 1.2 64.0n 1.2)
V31_d c31_d 0 PWL(0 0.0 4.0n 0.0 4.1n 1.2 8.0n 1.2 8.1n 0.0 12.0n 0.0 12.1n 1.2 16.0n 1.2 16.1n 0.0 20.0n 0.0 20.1n 1.2 24.0n 1.2 24.1n 0.0 28.0n 0.0 28.1n 1.2 32.0n 1.2 32.1n 0.0 36.0n 0.0 36.1n 1.2 40.0n 1.2 40.1n 0.0 44.0n 0.0 44.1n 1.2 48.0n 1.2 48.1n 0.0 52.0n 0.0 52.1n 1.2 56.0n 1.2 56.1n 0.0 60.0n 0.0 60.1n 1.2 64.0n 1.2)
X31 c31_a c31_b c31_c c31_d c31_y vdd 0 s5l_nor4_1
C31_y c31_y 0 10f
.include ../../design/netlists/s5l_o21ai_1.spice
V32_a1 c32_a1 0 PWL(0 0.0 16.0n 0.0 16.1n 1.2 32.0n 1.2)
V32_a2 c32_a2 0 PWL(0 0.0 8.0n 0.0 8.1n 1.2 16.0n 1.2 16.1n 0.0 24.0n 0.0 24.1n 1.2 32.0n 1.2)
V32_b1 c32_b1 0 PWL(0 0.0 4.0n 0.0 4.1n 1.2 8.0n 1.2 8.1n 0.0 12.0n 0.0 12.1n 1.2 16.0n 1.2 16.1n 0.0 20.0n 0.0 20.1n 1.2 24.0n 1.2 24.1n 0.0 28.0n 0.0 28.1n 1.2 32.0n 1.2)
X32 c32_a1 c32_a2 c32_b1 c32_y vdd 0 s5l_o21ai_1
C32_y c32_y 0 10f
.include ../../design/netlists/s5l_or2_1.spice
V33_a c33_a 0 PWL(0 0.0 8.0n 0.0 8.1n 1.2 16.0n 1.2)
V33_b c33_b 0 PWL(0 0.0 4.0n 0.0 4.1n 1.2 8.0n 1.2 8.1n 0.0 12.0n 0.0 12.1n 1.2 16.0n 1.2)
X33 c33_a c33_b c33_x vdd 0 s5l_or2_1
C33_x c33_x 0 10f
.include ../../design/netlists/s5l_or2_2.spice
V34_a c34_a 0 PWL(0 0.0 8.0n 0.0 8.1n 1.2 16.0n 1.2)
V34_b c34_b 0 PWL(0 0.0 4.0n 0.0 4.1n 1.2 8.0n 1.2 8.1n 0.0 12.0n 0.0 12.1n 1.2 16.0n 1.2)
X34 c34_a c34_b c34_x vdd 0 s5l_or2_2
C34_x c34_x 0 10f
.include ../../design/netlists/s5l_or3_1.spice
V35_a c35_a 0 PWL(0 0.0 16.0n 0.0 16.1n 1.2 32.0n 1.2)
V35_b c35_b 0 PWL(0 0.0 8.0n 0.0 8.1n 1.2 16.0n 1.2 16.1n 0.0 24.0n 0.0 24.1n 1.2 32.0n 1.2)
V35_c c35_c 0 PWL(0 0.0 4.0n 0.0 4.1n 1.2 8.0n 1.2 8.1n 0.0 12.0n 0.0 12.1n 1.2 16.0n 1.2 16.1n 0.0 20.0n 0.0 20.1n 1.2 24.0n 1.2 24.1n 0.0 28.0n 0.0 28.1n 1.2 32.0n 1.2)
X35 c35_a c35_b c35_c c35_x vdd 0 s5l_or3_1
C35_x c35_x 0 10f
.include ../../design/netlists/s5l_or3_2.spice
V36_a c36_a 0 PWL(0 0.0 16.0n 0.0 16.1n 1.2 32.0n 1.2)
V36_b c36_b 0 PWL(0 0.0 8.0n 0.0 8.1n 1.2 16.0n 1.2 16.1n 0.0 24.0n 0.0 24.1n 1.2 32.0n 1.2)
V36_c c36_c 0 PWL(0 0.0 4.0n 0.0 4.1n 1.2 8.0n 1.2 8.1n 0.0 12.0n 0.0 12.1n 1.2 16.0n 1.2 16.1n 0.0 20.0n 0.0 20.1n 1.2 24.0n 1.2 24.1n 0.0 28.0n 0.0 28.1n 1.2 32.0n 1.2)
X36 c36_a c36_b c36_c c36_x vdd 0 s5l_or3_2
C36_x c36_x 0 10f
.include ../../design/netlists/s5l_or4_1.spice
V37_a c37_a 0 PWL(0 0.0 32.0n 0.0 32.1n 1.2 64.0n 1.2)
V37_b c37_b 0 PWL(0 0.0 16.0n 0.0 16.1n 1.2 32.0n 1.2 32.1n 0.0 48.0n 0.0 48.1n 1.2 64.0n 1.2)
V37_c c37_c 0 PWL(0 0.0 8.0n 0.0 8.1n 1.2 16.0n 1.2 16.1n 0.0 24.0n 0.0 24.1n 1.2 32.0n 1.2 32.1n 0.0 40.0n 0.0 40.1n 1.2 48.0n 1.2 48.1n 0.0 56.0n 0.0 56.1n 1.2 64.0n 1.2)
V37_d c37_d 0 PWL(0 0.0 4.0n 0.0 4.1n 1.2 8.0n 1.2 8.1n 0.0 12.0n 0.0 12.1n 1.2 16.0n 1.2 16.1n 0.0 20.0n 0.0 20.1n 1.2 24.0n 1.2 24.1n 0.0 28.0n 0.0 28.1n 1.2 32.0n 1.2 32.1n 0.0 36.0n 0.0 36.1n 1.2 40.0n 1.2 40.1n 0.0 44.0n 0.0 44.1n 1.2 48.0n 1.2 48.1n 0.0 52.0n 0.0 52.1n 1.2 56.0n 1.2 56.1n 0.0 60.0n 0.0 60.1n 1.2 64.0n 1.2)
X37 c37_a c37_b c37_c c37_d c37_x vdd 0 s5l_or4_1
C37_x c37_x 0 10f
.include ../../design/netlists/s5l_xnor2_1.spice
V38_a c38_a 0 PWL(0 0.0 8.0n 0.0 8.1n 1.2 16.0n 1.2)
V38_b c38_b 0 PWL(0 0.0 4.0n 0.0 4.1n 1.2 8.0n 1.2 8.1n 0.0 12.0n 0.0 12.1n 1.2 16.0n 1.2)
X38 c38_a c38_b c38_y vdd 0 s5l_xnor2_1
C38_y c38_y 0 10f
.include ../../design/netlists/s5l_xor2_1.spice
V39_a c39_a 0 PWL(0 0.0 8.0n 0.0 8.1n 1.2 16.0n 1.2)
V39_b c39_b 0 PWL(0 0.0 4.0n 0.0 4.1n 1.2 8.0n 1.2 8.1n 0.0 12.0n 0.0 12.1n 1.2 16.0n 1.2)
X39 c39_a c39_b c39_x vdd 0 s5l_xor2_1
C39_x c39_x 0 10f
