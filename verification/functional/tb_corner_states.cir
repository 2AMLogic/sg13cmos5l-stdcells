* Generated by verification/functional/gen_functional.py; do not edit.
* Issue #124: every timing arc of all 40 cells in
* every side-input state that propagates it (208 in
* total, against 106 arcs in corners.request.json), one
* instance each, at the ratified characterization grid's worst point
* (input slew 2.5074 ns, output load 0.3 pF) -- see
* spec/decision-records/0005-timing-margin-spec-row.md.
* The 2.5074 ns slew is a 20-80% transition per the recorded
* Liberty's own thresholds, so the rail-to-rail ramp is 4.179 ns
* (slew / derate / span) -- the same stimulus klt characterize applies.
* Swept per corner by corner_states.request.json: process section,
* temperature, and the Vdd source. SIMULATED, never measured.
Vdd vdd 0 1.2
* Unitless 0 -> 1 -> 0 shape; Bin scales it to the corner's rail.
Vshape vshape 0 PWL(0 0 30.0n 0 34.179n 1 64.179n 1 68.358n 0 98.358n 0)
Bin vin 0 V = v(vdd)*v(vshape)
.include ../../design/netlists/s5l_a21o_1.spice
.include ../../design/netlists/s5l_a21o_2.spice
.include ../../design/netlists/s5l_a21oi_1.spice
.include ../../design/netlists/s5l_a21oi_2.spice
.include ../../design/netlists/s5l_a221oi_1.spice
.include ../../design/netlists/s5l_a22oi_1.spice
.include ../../design/netlists/s5l_and2_1.spice
.include ../../design/netlists/s5l_and2_2.spice
.include ../../design/netlists/s5l_and3_1.spice
.include ../../design/netlists/s5l_and3_2.spice
.include ../../design/netlists/s5l_and4_1.spice
.include ../../design/netlists/s5l_buf_1.spice
.include ../../design/netlists/s5l_buf_2.spice
.include ../../design/netlists/s5l_buf_4.spice
.include ../../design/netlists/s5l_inv_1.spice
.include ../../design/netlists/s5l_inv_2.spice
.include ../../design/netlists/s5l_inv_4.spice
.include ../../design/netlists/s5l_mux2_1.spice
.include ../../design/netlists/s5l_mux2_2.spice
.include ../../design/netlists/s5l_mux4_1.spice
.include ../../design/netlists/s5l_nand2_1.spice
.include ../../design/netlists/s5l_nand2_2.spice
.include ../../design/netlists/s5l_nand2b_1.spice
.include ../../design/netlists/s5l_nand3_1.spice
.include ../../design/netlists/s5l_nand3b_1.spice
.include ../../design/netlists/s5l_nand4_1.spice
.include ../../design/netlists/s5l_nor2_1.spice
.include ../../design/netlists/s5l_nor2_2.spice
.include ../../design/netlists/s5l_nor2b_1.spice
.include ../../design/netlists/s5l_nor3_1.spice
.include ../../design/netlists/s5l_nor3_2.spice
.include ../../design/netlists/s5l_nor4_1.spice
.include ../../design/netlists/s5l_o21ai_1.spice
.include ../../design/netlists/s5l_or2_1.spice
.include ../../design/netlists/s5l_or2_2.spice
.include ../../design/netlists/s5l_or3_1.spice
.include ../../design/netlists/s5l_or3_2.spice
.include ../../design/netlists/s5l_or4_1.spice
.include ../../design/netlists/s5l_xnor2_1.spice
.include ../../design/netlists/s5l_xor2_1.spice
* arc s5l_a21o_1 A1 -> X, holding A2=1 B1=0 [state 1 of 1, rising output on a rising A1]
X0 vin vdd 0 a0 vdd 0 s5l_a21o_1
C0 a0 0 0.3p
B0 n0 0 V = v(a0)/v(vdd)
* arc s5l_a21o_1 A2 -> X, holding A1=1 B1=0 [state 1 of 1, rising output on a rising A2]
X1 vdd vin 0 a1 vdd 0 s5l_a21o_1
C1 a1 0 0.3p
B1 n1 0 V = v(a1)/v(vdd)
* arc s5l_a21o_1 B1 -> X, holding A1=0 A2=0 [state 1 of 3, rising output on a rising B1]
X2 0 0 vin a2 vdd 0 s5l_a21o_1
C2 a2 0 0.3p
B2 n2 0 V = v(a2)/v(vdd)
* arc s5l_a21o_1 B1 -> X, holding A1=0 A2=1 [state 2 of 3, rising output on a rising B1]
X3 0 vdd vin a3 vdd 0 s5l_a21o_1
C3 a3 0 0.3p
B3 n3 0 V = v(a3)/v(vdd)
* arc s5l_a21o_1 B1 -> X, holding A1=1 A2=0 [state 3 of 3, rising output on a rising B1]
X4 vdd 0 vin a4 vdd 0 s5l_a21o_1
C4 a4 0 0.3p
B4 n4 0 V = v(a4)/v(vdd)
* arc s5l_a21o_2 A1 -> X, holding A2=1 B1=0 [state 1 of 1, rising output on a rising A1]
X5 vin vdd 0 a5 vdd 0 s5l_a21o_2
C5 a5 0 0.3p
B5 n5 0 V = v(a5)/v(vdd)
* arc s5l_a21o_2 A2 -> X, holding A1=1 B1=0 [state 1 of 1, rising output on a rising A2]
X6 vdd vin 0 a6 vdd 0 s5l_a21o_2
C6 a6 0 0.3p
B6 n6 0 V = v(a6)/v(vdd)
* arc s5l_a21o_2 B1 -> X, holding A1=0 A2=0 [state 1 of 3, rising output on a rising B1]
X7 0 0 vin a7 vdd 0 s5l_a21o_2
C7 a7 0 0.3p
B7 n7 0 V = v(a7)/v(vdd)
* arc s5l_a21o_2 B1 -> X, holding A1=0 A2=1 [state 2 of 3, rising output on a rising B1]
X8 0 vdd vin a8 vdd 0 s5l_a21o_2
C8 a8 0 0.3p
B8 n8 0 V = v(a8)/v(vdd)
* arc s5l_a21o_2 B1 -> X, holding A1=1 A2=0 [state 3 of 3, rising output on a rising B1]
X9 vdd 0 vin a9 vdd 0 s5l_a21o_2
C9 a9 0 0.3p
B9 n9 0 V = v(a9)/v(vdd)
* arc s5l_a21oi_1 A1 -> Y, holding A2=1 B1=0 [state 1 of 1, falling output on a rising A1]
X10 vin vdd 0 a10 vdd 0 s5l_a21oi_1
C10 a10 0 0.3p
B10 n10 0 V = v(a10)/v(vdd)
* arc s5l_a21oi_1 A2 -> Y, holding A1=1 B1=0 [state 1 of 1, falling output on a rising A2]
X11 vdd vin 0 a11 vdd 0 s5l_a21oi_1
C11 a11 0 0.3p
B11 n11 0 V = v(a11)/v(vdd)
* arc s5l_a21oi_1 B1 -> Y, holding A1=0 A2=0 [state 1 of 3, falling output on a rising B1]
X12 0 0 vin a12 vdd 0 s5l_a21oi_1
C12 a12 0 0.3p
B12 n12 0 V = v(a12)/v(vdd)
* arc s5l_a21oi_1 B1 -> Y, holding A1=0 A2=1 [state 2 of 3, falling output on a rising B1]
X13 0 vdd vin a13 vdd 0 s5l_a21oi_1
C13 a13 0 0.3p
B13 n13 0 V = v(a13)/v(vdd)
* arc s5l_a21oi_1 B1 -> Y, holding A1=1 A2=0 [state 3 of 3, falling output on a rising B1]
X14 vdd 0 vin a14 vdd 0 s5l_a21oi_1
C14 a14 0 0.3p
B14 n14 0 V = v(a14)/v(vdd)
* arc s5l_a21oi_2 A1 -> Y, holding A2=1 B1=0 [state 1 of 1, falling output on a rising A1]
X15 vin vdd 0 a15 vdd 0 s5l_a21oi_2
C15 a15 0 0.3p
B15 n15 0 V = v(a15)/v(vdd)
* arc s5l_a21oi_2 A2 -> Y, holding A1=1 B1=0 [state 1 of 1, falling output on a rising A2]
X16 vdd vin 0 a16 vdd 0 s5l_a21oi_2
C16 a16 0 0.3p
B16 n16 0 V = v(a16)/v(vdd)
* arc s5l_a21oi_2 B1 -> Y, holding A1=0 A2=0 [state 1 of 3, falling output on a rising B1]
X17 0 0 vin a17 vdd 0 s5l_a21oi_2
C17 a17 0 0.3p
B17 n17 0 V = v(a17)/v(vdd)
* arc s5l_a21oi_2 B1 -> Y, holding A1=0 A2=1 [state 2 of 3, falling output on a rising B1]
X18 0 vdd vin a18 vdd 0 s5l_a21oi_2
C18 a18 0 0.3p
B18 n18 0 V = v(a18)/v(vdd)
* arc s5l_a21oi_2 B1 -> Y, holding A1=1 A2=0 [state 3 of 3, falling output on a rising B1]
X19 vdd 0 vin a19 vdd 0 s5l_a21oi_2
C19 a19 0 0.3p
B19 n19 0 V = v(a19)/v(vdd)
* arc s5l_a22oi_1 A1 -> Y, holding A2=1 B1=0 B2=0 [state 1 of 3, falling output on a rising A1]
X20 vin vdd 0 0 a20 vdd 0 s5l_a22oi_1
C20 a20 0 0.3p
B20 n20 0 V = v(a20)/v(vdd)
* arc s5l_a22oi_1 A1 -> Y, holding A2=1 B1=0 B2=1 [state 2 of 3, falling output on a rising A1]
X21 vin vdd 0 vdd a21 vdd 0 s5l_a22oi_1
C21 a21 0 0.3p
B21 n21 0 V = v(a21)/v(vdd)
* arc s5l_a22oi_1 A1 -> Y, holding A2=1 B1=1 B2=0 [state 3 of 3, falling output on a rising A1]
X22 vin vdd vdd 0 a22 vdd 0 s5l_a22oi_1
C22 a22 0 0.3p
B22 n22 0 V = v(a22)/v(vdd)
* arc s5l_a22oi_1 A2 -> Y, holding A1=1 B1=0 B2=0 [state 1 of 3, falling output on a rising A2]
X23 vdd vin 0 0 a23 vdd 0 s5l_a22oi_1
C23 a23 0 0.3p
B23 n23 0 V = v(a23)/v(vdd)
* arc s5l_a22oi_1 A2 -> Y, holding A1=1 B1=0 B2=1 [state 2 of 3, falling output on a rising A2]
X24 vdd vin 0 vdd a24 vdd 0 s5l_a22oi_1
C24 a24 0 0.3p
B24 n24 0 V = v(a24)/v(vdd)
* arc s5l_a22oi_1 A2 -> Y, holding A1=1 B1=1 B2=0 [state 3 of 3, falling output on a rising A2]
X25 vdd vin vdd 0 a25 vdd 0 s5l_a22oi_1
C25 a25 0 0.3p
B25 n25 0 V = v(a25)/v(vdd)
* arc s5l_a22oi_1 B1 -> Y, holding A1=0 A2=0 B2=1 [state 1 of 3, falling output on a rising B1]
X26 0 0 vin vdd a26 vdd 0 s5l_a22oi_1
C26 a26 0 0.3p
B26 n26 0 V = v(a26)/v(vdd)
* arc s5l_a22oi_1 B1 -> Y, holding A1=0 A2=1 B2=1 [state 2 of 3, falling output on a rising B1]
X27 0 vdd vin vdd a27 vdd 0 s5l_a22oi_1
C27 a27 0 0.3p
B27 n27 0 V = v(a27)/v(vdd)
* arc s5l_a22oi_1 B1 -> Y, holding A1=1 A2=0 B2=1 [state 3 of 3, falling output on a rising B1]
X28 vdd 0 vin vdd a28 vdd 0 s5l_a22oi_1
C28 a28 0 0.3p
B28 n28 0 V = v(a28)/v(vdd)
* arc s5l_a22oi_1 B2 -> Y, holding A1=0 A2=0 B1=1 [state 1 of 3, falling output on a rising B2]
X29 0 0 vdd vin a29 vdd 0 s5l_a22oi_1
C29 a29 0 0.3p
B29 n29 0 V = v(a29)/v(vdd)
* arc s5l_a22oi_1 B2 -> Y, holding A1=0 A2=1 B1=1 [state 2 of 3, falling output on a rising B2]
X30 0 vdd vdd vin a30 vdd 0 s5l_a22oi_1
C30 a30 0 0.3p
B30 n30 0 V = v(a30)/v(vdd)
* arc s5l_a22oi_1 B2 -> Y, holding A1=1 A2=0 B1=1 [state 3 of 3, falling output on a rising B2]
X31 vdd 0 vdd vin a31 vdd 0 s5l_a22oi_1
C31 a31 0 0.3p
B31 n31 0 V = v(a31)/v(vdd)
* arc s5l_a221oi_1 A1 -> Y, holding A2=1 B1=0 B2=0 C1=0 [state 1 of 3, falling output on a rising A1]
X32 vin vdd 0 0 0 a32 vdd 0 s5l_a221oi_1
C32 a32 0 0.3p
B32 n32 0 V = v(a32)/v(vdd)
* arc s5l_a221oi_1 A1 -> Y, holding A2=1 B1=0 B2=1 C1=0 [state 2 of 3, falling output on a rising A1]
X33 vin vdd 0 vdd 0 a33 vdd 0 s5l_a221oi_1
C33 a33 0 0.3p
B33 n33 0 V = v(a33)/v(vdd)
* arc s5l_a221oi_1 A1 -> Y, holding A2=1 B1=1 B2=0 C1=0 [state 3 of 3, falling output on a rising A1]
X34 vin vdd vdd 0 0 a34 vdd 0 s5l_a221oi_1
C34 a34 0 0.3p
B34 n34 0 V = v(a34)/v(vdd)
* arc s5l_a221oi_1 A2 -> Y, holding A1=1 B1=0 B2=0 C1=0 [state 1 of 3, falling output on a rising A2]
X35 vdd vin 0 0 0 a35 vdd 0 s5l_a221oi_1
C35 a35 0 0.3p
B35 n35 0 V = v(a35)/v(vdd)
* arc s5l_a221oi_1 A2 -> Y, holding A1=1 B1=0 B2=1 C1=0 [state 2 of 3, falling output on a rising A2]
X36 vdd vin 0 vdd 0 a36 vdd 0 s5l_a221oi_1
C36 a36 0 0.3p
B36 n36 0 V = v(a36)/v(vdd)
* arc s5l_a221oi_1 A2 -> Y, holding A1=1 B1=1 B2=0 C1=0 [state 3 of 3, falling output on a rising A2]
X37 vdd vin vdd 0 0 a37 vdd 0 s5l_a221oi_1
C37 a37 0 0.3p
B37 n37 0 V = v(a37)/v(vdd)
* arc s5l_a221oi_1 B1 -> Y, holding A1=0 A2=0 B2=1 C1=0 [state 1 of 3, falling output on a rising B1]
X38 0 0 vin vdd 0 a38 vdd 0 s5l_a221oi_1
C38 a38 0 0.3p
B38 n38 0 V = v(a38)/v(vdd)
* arc s5l_a221oi_1 B1 -> Y, holding A1=0 A2=1 B2=1 C1=0 [state 2 of 3, falling output on a rising B1]
X39 0 vdd vin vdd 0 a39 vdd 0 s5l_a221oi_1
C39 a39 0 0.3p
B39 n39 0 V = v(a39)/v(vdd)
* arc s5l_a221oi_1 B1 -> Y, holding A1=1 A2=0 B2=1 C1=0 [state 3 of 3, falling output on a rising B1]
X40 vdd 0 vin vdd 0 a40 vdd 0 s5l_a221oi_1
C40 a40 0 0.3p
B40 n40 0 V = v(a40)/v(vdd)
* arc s5l_a221oi_1 B2 -> Y, holding A1=0 A2=0 B1=1 C1=0 [state 1 of 3, falling output on a rising B2]
X41 0 0 vdd vin 0 a41 vdd 0 s5l_a221oi_1
C41 a41 0 0.3p
B41 n41 0 V = v(a41)/v(vdd)
* arc s5l_a221oi_1 B2 -> Y, holding A1=0 A2=1 B1=1 C1=0 [state 2 of 3, falling output on a rising B2]
X42 0 vdd vdd vin 0 a42 vdd 0 s5l_a221oi_1
C42 a42 0 0.3p
B42 n42 0 V = v(a42)/v(vdd)
* arc s5l_a221oi_1 B2 -> Y, holding A1=1 A2=0 B1=1 C1=0 [state 3 of 3, falling output on a rising B2]
X43 vdd 0 vdd vin 0 a43 vdd 0 s5l_a221oi_1
C43 a43 0 0.3p
B43 n43 0 V = v(a43)/v(vdd)
* arc s5l_a221oi_1 C1 -> Y, holding A1=0 A2=0 B1=0 B2=0 [state 1 of 9, falling output on a rising C1]
X44 0 0 0 0 vin a44 vdd 0 s5l_a221oi_1
C44 a44 0 0.3p
B44 n44 0 V = v(a44)/v(vdd)
* arc s5l_a221oi_1 C1 -> Y, holding A1=0 A2=0 B1=0 B2=1 [state 2 of 9, falling output on a rising C1]
X45 0 0 0 vdd vin a45 vdd 0 s5l_a221oi_1
C45 a45 0 0.3p
B45 n45 0 V = v(a45)/v(vdd)
* arc s5l_a221oi_1 C1 -> Y, holding A1=0 A2=0 B1=1 B2=0 [state 3 of 9, falling output on a rising C1]
X46 0 0 vdd 0 vin a46 vdd 0 s5l_a221oi_1
C46 a46 0 0.3p
B46 n46 0 V = v(a46)/v(vdd)
* arc s5l_a221oi_1 C1 -> Y, holding A1=0 A2=1 B1=0 B2=0 [state 4 of 9, falling output on a rising C1]
X47 0 vdd 0 0 vin a47 vdd 0 s5l_a221oi_1
C47 a47 0 0.3p
B47 n47 0 V = v(a47)/v(vdd)
* arc s5l_a221oi_1 C1 -> Y, holding A1=0 A2=1 B1=0 B2=1 [state 5 of 9, falling output on a rising C1]
X48 0 vdd 0 vdd vin a48 vdd 0 s5l_a221oi_1
C48 a48 0 0.3p
B48 n48 0 V = v(a48)/v(vdd)
* arc s5l_a221oi_1 C1 -> Y, holding A1=0 A2=1 B1=1 B2=0 [state 6 of 9, falling output on a rising C1]
X49 0 vdd vdd 0 vin a49 vdd 0 s5l_a221oi_1
C49 a49 0 0.3p
B49 n49 0 V = v(a49)/v(vdd)
* arc s5l_a221oi_1 C1 -> Y, holding A1=1 A2=0 B1=0 B2=0 [state 7 of 9, falling output on a rising C1]
X50 vdd 0 0 0 vin a50 vdd 0 s5l_a221oi_1
C50 a50 0 0.3p
B50 n50 0 V = v(a50)/v(vdd)
* arc s5l_a221oi_1 C1 -> Y, holding A1=1 A2=0 B1=0 B2=1 [state 8 of 9, falling output on a rising C1]
X51 vdd 0 0 vdd vin a51 vdd 0 s5l_a221oi_1
C51 a51 0 0.3p
B51 n51 0 V = v(a51)/v(vdd)
* arc s5l_a221oi_1 C1 -> Y, holding A1=1 A2=0 B1=1 B2=0 [state 9 of 9, falling output on a rising C1]
X52 vdd 0 vdd 0 vin a52 vdd 0 s5l_a221oi_1
C52 a52 0 0.3p
B52 n52 0 V = v(a52)/v(vdd)
* arc s5l_and2_1 A -> X, holding B=1 [state 1 of 1, rising output on a rising A]
X53 vin vdd a53 vdd 0 s5l_and2_1
C53 a53 0 0.3p
B53 n53 0 V = v(a53)/v(vdd)
* arc s5l_and2_1 B -> X, holding A=1 [state 1 of 1, rising output on a rising B]
X54 vdd vin a54 vdd 0 s5l_and2_1
C54 a54 0 0.3p
B54 n54 0 V = v(a54)/v(vdd)
* arc s5l_and2_2 A -> X, holding B=1 [state 1 of 1, rising output on a rising A]
X55 vin vdd a55 vdd 0 s5l_and2_2
C55 a55 0 0.3p
B55 n55 0 V = v(a55)/v(vdd)
* arc s5l_and2_2 B -> X, holding A=1 [state 1 of 1, rising output on a rising B]
X56 vdd vin a56 vdd 0 s5l_and2_2
C56 a56 0 0.3p
B56 n56 0 V = v(a56)/v(vdd)
* arc s5l_and3_1 A -> X, holding B=1 C=1 [state 1 of 1, rising output on a rising A]
X57 vin vdd vdd a57 vdd 0 s5l_and3_1
C57 a57 0 0.3p
B57 n57 0 V = v(a57)/v(vdd)
* arc s5l_and3_1 B -> X, holding A=1 C=1 [state 1 of 1, rising output on a rising B]
X58 vdd vin vdd a58 vdd 0 s5l_and3_1
C58 a58 0 0.3p
B58 n58 0 V = v(a58)/v(vdd)
* arc s5l_and3_1 C -> X, holding A=1 B=1 [state 1 of 1, rising output on a rising C]
X59 vdd vdd vin a59 vdd 0 s5l_and3_1
C59 a59 0 0.3p
B59 n59 0 V = v(a59)/v(vdd)
* arc s5l_and3_2 A -> X, holding B=1 C=1 [state 1 of 1, rising output on a rising A]
X60 vin vdd vdd a60 vdd 0 s5l_and3_2
C60 a60 0 0.3p
B60 n60 0 V = v(a60)/v(vdd)
* arc s5l_and3_2 B -> X, holding A=1 C=1 [state 1 of 1, rising output on a rising B]
X61 vdd vin vdd a61 vdd 0 s5l_and3_2
C61 a61 0 0.3p
B61 n61 0 V = v(a61)/v(vdd)
* arc s5l_and3_2 C -> X, holding A=1 B=1 [state 1 of 1, rising output on a rising C]
X62 vdd vdd vin a62 vdd 0 s5l_and3_2
C62 a62 0 0.3p
B62 n62 0 V = v(a62)/v(vdd)
* arc s5l_and4_1 A -> X, holding B=1 C=1 D=1 [state 1 of 1, rising output on a rising A]
X63 vin vdd vdd vdd a63 vdd 0 s5l_and4_1
C63 a63 0 0.3p
B63 n63 0 V = v(a63)/v(vdd)
* arc s5l_and4_1 B -> X, holding A=1 C=1 D=1 [state 1 of 1, rising output on a rising B]
X64 vdd vin vdd vdd a64 vdd 0 s5l_and4_1
C64 a64 0 0.3p
B64 n64 0 V = v(a64)/v(vdd)
* arc s5l_and4_1 C -> X, holding A=1 B=1 D=1 [state 1 of 1, rising output on a rising C]
X65 vdd vdd vin vdd a65 vdd 0 s5l_and4_1
C65 a65 0 0.3p
B65 n65 0 V = v(a65)/v(vdd)
* arc s5l_and4_1 D -> X, holding A=1 B=1 C=1 [state 1 of 1, rising output on a rising D]
X66 vdd vdd vdd vin a66 vdd 0 s5l_and4_1
C66 a66 0 0.3p
B66 n66 0 V = v(a66)/v(vdd)
* arc s5l_buf_1 A -> X [state 1 of 1, rising output on a rising A]
X67 vin a67 vdd 0 s5l_buf_1
C67 a67 0 0.3p
B67 n67 0 V = v(a67)/v(vdd)
* arc s5l_buf_2 A -> X [state 1 of 1, rising output on a rising A]
X68 vin a68 vdd 0 s5l_buf_2
C68 a68 0 0.3p
B68 n68 0 V = v(a68)/v(vdd)
* arc s5l_buf_4 A -> X [state 1 of 1, rising output on a rising A]
X69 vin a69 vdd 0 s5l_buf_4
C69 a69 0 0.3p
B69 n69 0 V = v(a69)/v(vdd)
* arc s5l_inv_1 A -> Y [state 1 of 1, falling output on a rising A]
X70 vin a70 vdd 0 s5l_inv_1
C70 a70 0 0.3p
B70 n70 0 V = v(a70)/v(vdd)
* arc s5l_inv_2 A -> Y [state 1 of 1, falling output on a rising A]
X71 vin a71 vdd 0 s5l_inv_2
C71 a71 0 0.3p
B71 n71 0 V = v(a71)/v(vdd)
* arc s5l_inv_4 A -> Y [state 1 of 1, falling output on a rising A]
X72 vin a72 vdd 0 s5l_inv_4
C72 a72 0 0.3p
B72 n72 0 V = v(a72)/v(vdd)
* arc s5l_mux2_1 A0 -> X, holding A1=0 S=0 [state 1 of 2, rising output on a rising A0]
X73 vin 0 0 a73 vdd 0 s5l_mux2_1
C73 a73 0 0.3p
B73 n73 0 V = v(a73)/v(vdd)
* arc s5l_mux2_1 A0 -> X, holding A1=1 S=0 [state 2 of 2, rising output on a rising A0]
X74 vin vdd 0 a74 vdd 0 s5l_mux2_1
C74 a74 0 0.3p
B74 n74 0 V = v(a74)/v(vdd)
* arc s5l_mux2_1 A1 -> X, holding A0=0 S=1 [state 1 of 2, rising output on a rising A1]
X75 0 vin vdd a75 vdd 0 s5l_mux2_1
C75 a75 0 0.3p
B75 n75 0 V = v(a75)/v(vdd)
* arc s5l_mux2_1 A1 -> X, holding A0=1 S=1 [state 2 of 2, rising output on a rising A1]
X76 vdd vin vdd a76 vdd 0 s5l_mux2_1
C76 a76 0 0.3p
B76 n76 0 V = v(a76)/v(vdd)
* arc s5l_mux2_1 S -> X, holding A0=0 A1=1 [state 1 of 2, rising output on a rising S]
X77 0 vdd vin a77 vdd 0 s5l_mux2_1
C77 a77 0 0.3p
B77 n77 0 V = v(a77)/v(vdd)
* arc s5l_mux2_1 S -> X, holding A0=1 A1=0 [state 2 of 2, falling output on a rising S]
X78 vdd 0 vin a78 vdd 0 s5l_mux2_1
C78 a78 0 0.3p
B78 n78 0 V = v(a78)/v(vdd)
* arc s5l_mux2_2 A0 -> X, holding A1=0 S=0 [state 1 of 2, rising output on a rising A0]
X79 vin 0 0 a79 vdd 0 s5l_mux2_2
C79 a79 0 0.3p
B79 n79 0 V = v(a79)/v(vdd)
* arc s5l_mux2_2 A0 -> X, holding A1=1 S=0 [state 2 of 2, rising output on a rising A0]
X80 vin vdd 0 a80 vdd 0 s5l_mux2_2
C80 a80 0 0.3p
B80 n80 0 V = v(a80)/v(vdd)
* arc s5l_mux2_2 A1 -> X, holding A0=0 S=1 [state 1 of 2, rising output on a rising A1]
X81 0 vin vdd a81 vdd 0 s5l_mux2_2
C81 a81 0 0.3p
B81 n81 0 V = v(a81)/v(vdd)
* arc s5l_mux2_2 A1 -> X, holding A0=1 S=1 [state 2 of 2, rising output on a rising A1]
X82 vdd vin vdd a82 vdd 0 s5l_mux2_2
C82 a82 0 0.3p
B82 n82 0 V = v(a82)/v(vdd)
* arc s5l_mux2_2 S -> X, holding A0=0 A1=1 [state 1 of 2, rising output on a rising S]
X83 0 vdd vin a83 vdd 0 s5l_mux2_2
C83 a83 0 0.3p
B83 n83 0 V = v(a83)/v(vdd)
* arc s5l_mux2_2 S -> X, holding A0=1 A1=0 [state 2 of 2, falling output on a rising S]
X84 vdd 0 vin a84 vdd 0 s5l_mux2_2
C84 a84 0 0.3p
B84 n84 0 V = v(a84)/v(vdd)
* arc s5l_mux4_1 A0 -> X, holding A1=0 A2=0 A3=0 S0=0 S1=0 [state 1 of 8, rising output on a rising A0]
X85 vin 0 0 0 0 0 a85 vdd 0 s5l_mux4_1
C85 a85 0 0.3p
B85 n85 0 V = v(a85)/v(vdd)
* arc s5l_mux4_1 A0 -> X, holding A1=0 A2=0 A3=1 S0=0 S1=0 [state 2 of 8, rising output on a rising A0]
X86 vin 0 0 vdd 0 0 a86 vdd 0 s5l_mux4_1
C86 a86 0 0.3p
B86 n86 0 V = v(a86)/v(vdd)
* arc s5l_mux4_1 A0 -> X, holding A1=0 A2=1 A3=0 S0=0 S1=0 [state 3 of 8, rising output on a rising A0]
X87 vin 0 vdd 0 0 0 a87 vdd 0 s5l_mux4_1
C87 a87 0 0.3p
B87 n87 0 V = v(a87)/v(vdd)
* arc s5l_mux4_1 A0 -> X, holding A1=0 A2=1 A3=1 S0=0 S1=0 [state 4 of 8, rising output on a rising A0]
X88 vin 0 vdd vdd 0 0 a88 vdd 0 s5l_mux4_1
C88 a88 0 0.3p
B88 n88 0 V = v(a88)/v(vdd)
* arc s5l_mux4_1 A0 -> X, holding A1=1 A2=0 A3=0 S0=0 S1=0 [state 5 of 8, rising output on a rising A0]
X89 vin vdd 0 0 0 0 a89 vdd 0 s5l_mux4_1
C89 a89 0 0.3p
B89 n89 0 V = v(a89)/v(vdd)
* arc s5l_mux4_1 A0 -> X, holding A1=1 A2=0 A3=1 S0=0 S1=0 [state 6 of 8, rising output on a rising A0]
X90 vin vdd 0 vdd 0 0 a90 vdd 0 s5l_mux4_1
C90 a90 0 0.3p
B90 n90 0 V = v(a90)/v(vdd)
* arc s5l_mux4_1 A0 -> X, holding A1=1 A2=1 A3=0 S0=0 S1=0 [state 7 of 8, rising output on a rising A0]
X91 vin vdd vdd 0 0 0 a91 vdd 0 s5l_mux4_1
C91 a91 0 0.3p
B91 n91 0 V = v(a91)/v(vdd)
* arc s5l_mux4_1 A0 -> X, holding A1=1 A2=1 A3=1 S0=0 S1=0 [state 8 of 8, rising output on a rising A0]
X92 vin vdd vdd vdd 0 0 a92 vdd 0 s5l_mux4_1
C92 a92 0 0.3p
B92 n92 0 V = v(a92)/v(vdd)
* arc s5l_mux4_1 A1 -> X, holding A0=0 A2=0 A3=0 S0=1 S1=0 [state 1 of 8, rising output on a rising A1]
X93 0 vin 0 0 vdd 0 a93 vdd 0 s5l_mux4_1
C93 a93 0 0.3p
B93 n93 0 V = v(a93)/v(vdd)
* arc s5l_mux4_1 A1 -> X, holding A0=0 A2=0 A3=1 S0=1 S1=0 [state 2 of 8, rising output on a rising A1]
X94 0 vin 0 vdd vdd 0 a94 vdd 0 s5l_mux4_1
C94 a94 0 0.3p
B94 n94 0 V = v(a94)/v(vdd)
* arc s5l_mux4_1 A1 -> X, holding A0=0 A2=1 A3=0 S0=1 S1=0 [state 3 of 8, rising output on a rising A1]
X95 0 vin vdd 0 vdd 0 a95 vdd 0 s5l_mux4_1
C95 a95 0 0.3p
B95 n95 0 V = v(a95)/v(vdd)
* arc s5l_mux4_1 A1 -> X, holding A0=0 A2=1 A3=1 S0=1 S1=0 [state 4 of 8, rising output on a rising A1]
X96 0 vin vdd vdd vdd 0 a96 vdd 0 s5l_mux4_1
C96 a96 0 0.3p
B96 n96 0 V = v(a96)/v(vdd)
* arc s5l_mux4_1 A1 -> X, holding A0=1 A2=0 A3=0 S0=1 S1=0 [state 5 of 8, rising output on a rising A1]
X97 vdd vin 0 0 vdd 0 a97 vdd 0 s5l_mux4_1
C97 a97 0 0.3p
B97 n97 0 V = v(a97)/v(vdd)
* arc s5l_mux4_1 A1 -> X, holding A0=1 A2=0 A3=1 S0=1 S1=0 [state 6 of 8, rising output on a rising A1]
X98 vdd vin 0 vdd vdd 0 a98 vdd 0 s5l_mux4_1
C98 a98 0 0.3p
B98 n98 0 V = v(a98)/v(vdd)
* arc s5l_mux4_1 A1 -> X, holding A0=1 A2=1 A3=0 S0=1 S1=0 [state 7 of 8, rising output on a rising A1]
X99 vdd vin vdd 0 vdd 0 a99 vdd 0 s5l_mux4_1
C99 a99 0 0.3p
B99 n99 0 V = v(a99)/v(vdd)
* arc s5l_mux4_1 A1 -> X, holding A0=1 A2=1 A3=1 S0=1 S1=0 [state 8 of 8, rising output on a rising A1]
X100 vdd vin vdd vdd vdd 0 a100 vdd 0 s5l_mux4_1
C100 a100 0 0.3p
B100 n100 0 V = v(a100)/v(vdd)
* arc s5l_mux4_1 A2 -> X, holding A0=0 A1=0 A3=0 S0=0 S1=1 [state 1 of 8, rising output on a rising A2]
X101 0 0 vin 0 0 vdd a101 vdd 0 s5l_mux4_1
C101 a101 0 0.3p
B101 n101 0 V = v(a101)/v(vdd)
* arc s5l_mux4_1 A2 -> X, holding A0=0 A1=0 A3=1 S0=0 S1=1 [state 2 of 8, rising output on a rising A2]
X102 0 0 vin vdd 0 vdd a102 vdd 0 s5l_mux4_1
C102 a102 0 0.3p
B102 n102 0 V = v(a102)/v(vdd)
* arc s5l_mux4_1 A2 -> X, holding A0=0 A1=1 A3=0 S0=0 S1=1 [state 3 of 8, rising output on a rising A2]
X103 0 vdd vin 0 0 vdd a103 vdd 0 s5l_mux4_1
C103 a103 0 0.3p
B103 n103 0 V = v(a103)/v(vdd)
* arc s5l_mux4_1 A2 -> X, holding A0=0 A1=1 A3=1 S0=0 S1=1 [state 4 of 8, rising output on a rising A2]
X104 0 vdd vin vdd 0 vdd a104 vdd 0 s5l_mux4_1
C104 a104 0 0.3p
B104 n104 0 V = v(a104)/v(vdd)
* arc s5l_mux4_1 A2 -> X, holding A0=1 A1=0 A3=0 S0=0 S1=1 [state 5 of 8, rising output on a rising A2]
X105 vdd 0 vin 0 0 vdd a105 vdd 0 s5l_mux4_1
C105 a105 0 0.3p
B105 n105 0 V = v(a105)/v(vdd)
* arc s5l_mux4_1 A2 -> X, holding A0=1 A1=0 A3=1 S0=0 S1=1 [state 6 of 8, rising output on a rising A2]
X106 vdd 0 vin vdd 0 vdd a106 vdd 0 s5l_mux4_1
C106 a106 0 0.3p
B106 n106 0 V = v(a106)/v(vdd)
* arc s5l_mux4_1 A2 -> X, holding A0=1 A1=1 A3=0 S0=0 S1=1 [state 7 of 8, rising output on a rising A2]
X107 vdd vdd vin 0 0 vdd a107 vdd 0 s5l_mux4_1
C107 a107 0 0.3p
B107 n107 0 V = v(a107)/v(vdd)
* arc s5l_mux4_1 A2 -> X, holding A0=1 A1=1 A3=1 S0=0 S1=1 [state 8 of 8, rising output on a rising A2]
X108 vdd vdd vin vdd 0 vdd a108 vdd 0 s5l_mux4_1
C108 a108 0 0.3p
B108 n108 0 V = v(a108)/v(vdd)
* arc s5l_mux4_1 A3 -> X, holding A0=0 A1=0 A2=0 S0=1 S1=1 [state 1 of 8, rising output on a rising A3]
X109 0 0 0 vin vdd vdd a109 vdd 0 s5l_mux4_1
C109 a109 0 0.3p
B109 n109 0 V = v(a109)/v(vdd)
* arc s5l_mux4_1 A3 -> X, holding A0=0 A1=0 A2=1 S0=1 S1=1 [state 2 of 8, rising output on a rising A3]
X110 0 0 vdd vin vdd vdd a110 vdd 0 s5l_mux4_1
C110 a110 0 0.3p
B110 n110 0 V = v(a110)/v(vdd)
* arc s5l_mux4_1 A3 -> X, holding A0=0 A1=1 A2=0 S0=1 S1=1 [state 3 of 8, rising output on a rising A3]
X111 0 vdd 0 vin vdd vdd a111 vdd 0 s5l_mux4_1
C111 a111 0 0.3p
B111 n111 0 V = v(a111)/v(vdd)
* arc s5l_mux4_1 A3 -> X, holding A0=0 A1=1 A2=1 S0=1 S1=1 [state 4 of 8, rising output on a rising A3]
X112 0 vdd vdd vin vdd vdd a112 vdd 0 s5l_mux4_1
C112 a112 0 0.3p
B112 n112 0 V = v(a112)/v(vdd)
* arc s5l_mux4_1 A3 -> X, holding A0=1 A1=0 A2=0 S0=1 S1=1 [state 5 of 8, rising output on a rising A3]
X113 vdd 0 0 vin vdd vdd a113 vdd 0 s5l_mux4_1
C113 a113 0 0.3p
B113 n113 0 V = v(a113)/v(vdd)
* arc s5l_mux4_1 A3 -> X, holding A0=1 A1=0 A2=1 S0=1 S1=1 [state 6 of 8, rising output on a rising A3]
X114 vdd 0 vdd vin vdd vdd a114 vdd 0 s5l_mux4_1
C114 a114 0 0.3p
B114 n114 0 V = v(a114)/v(vdd)
* arc s5l_mux4_1 A3 -> X, holding A0=1 A1=1 A2=0 S0=1 S1=1 [state 7 of 8, rising output on a rising A3]
X115 vdd vdd 0 vin vdd vdd a115 vdd 0 s5l_mux4_1
C115 a115 0 0.3p
B115 n115 0 V = v(a115)/v(vdd)
* arc s5l_mux4_1 A3 -> X, holding A0=1 A1=1 A2=1 S0=1 S1=1 [state 8 of 8, rising output on a rising A3]
X116 vdd vdd vdd vin vdd vdd a116 vdd 0 s5l_mux4_1
C116 a116 0 0.3p
B116 n116 0 V = v(a116)/v(vdd)
* arc s5l_mux4_1 S0 -> X, holding A0=0 A1=0 A2=0 A3=1 S1=1 [state 1 of 16, rising output on a rising S0]
X117 0 0 0 vdd vin vdd a117 vdd 0 s5l_mux4_1
C117 a117 0 0.3p
B117 n117 0 V = v(a117)/v(vdd)
* arc s5l_mux4_1 S0 -> X, holding A0=0 A1=0 A2=1 A3=0 S1=1 [state 2 of 16, falling output on a rising S0]
X118 0 0 vdd 0 vin vdd a118 vdd 0 s5l_mux4_1
C118 a118 0 0.3p
B118 n118 0 V = v(a118)/v(vdd)
* arc s5l_mux4_1 S0 -> X, holding A0=0 A1=1 A2=0 A3=0 S1=0 [state 3 of 16, rising output on a rising S0]
X119 0 vdd 0 0 vin 0 a119 vdd 0 s5l_mux4_1
C119 a119 0 0.3p
B119 n119 0 V = v(a119)/v(vdd)
* arc s5l_mux4_1 S0 -> X, holding A0=0 A1=1 A2=0 A3=1 S1=0 [state 4 of 16, rising output on a rising S0]
X120 0 vdd 0 vdd vin 0 a120 vdd 0 s5l_mux4_1
C120 a120 0 0.3p
B120 n120 0 V = v(a120)/v(vdd)
* arc s5l_mux4_1 S0 -> X, holding A0=0 A1=1 A2=0 A3=1 S1=1 [state 5 of 16, rising output on a rising S0]
X121 0 vdd 0 vdd vin vdd a121 vdd 0 s5l_mux4_1
C121 a121 0 0.3p
B121 n121 0 V = v(a121)/v(vdd)
* arc s5l_mux4_1 S0 -> X, holding A0=0 A1=1 A2=1 A3=0 S1=0 [state 6 of 16, rising output on a rising S0]
X122 0 vdd vdd 0 vin 0 a122 vdd 0 s5l_mux4_1
C122 a122 0 0.3p
B122 n122 0 V = v(a122)/v(vdd)
* arc s5l_mux4_1 S0 -> X, holding A0=0 A1=1 A2=1 A3=0 S1=1 [state 7 of 16, falling output on a rising S0]
X123 0 vdd vdd 0 vin vdd a123 vdd 0 s5l_mux4_1
C123 a123 0 0.3p
B123 n123 0 V = v(a123)/v(vdd)
* arc s5l_mux4_1 S0 -> X, holding A0=0 A1=1 A2=1 A3=1 S1=0 [state 8 of 16, rising output on a rising S0]
X124 0 vdd vdd vdd vin 0 a124 vdd 0 s5l_mux4_1
C124 a124 0 0.3p
B124 n124 0 V = v(a124)/v(vdd)
* arc s5l_mux4_1 S0 -> X, holding A0=1 A1=0 A2=0 A3=0 S1=0 [state 9 of 16, falling output on a rising S0]
X125 vdd 0 0 0 vin 0 a125 vdd 0 s5l_mux4_1
C125 a125 0 0.3p
B125 n125 0 V = v(a125)/v(vdd)
* arc s5l_mux4_1 S0 -> X, holding A0=1 A1=0 A2=0 A3=1 S1=0 [state 10 of 16, falling output on a rising S0]
X126 vdd 0 0 vdd vin 0 a126 vdd 0 s5l_mux4_1
C126 a126 0 0.3p
B126 n126 0 V = v(a126)/v(vdd)
* arc s5l_mux4_1 S0 -> X, holding A0=1 A1=0 A2=0 A3=1 S1=1 [state 11 of 16, rising output on a rising S0]
X127 vdd 0 0 vdd vin vdd a127 vdd 0 s5l_mux4_1
C127 a127 0 0.3p
B127 n127 0 V = v(a127)/v(vdd)
* arc s5l_mux4_1 S0 -> X, holding A0=1 A1=0 A2=1 A3=0 S1=0 [state 12 of 16, falling output on a rising S0]
X128 vdd 0 vdd 0 vin 0 a128 vdd 0 s5l_mux4_1
C128 a128 0 0.3p
B128 n128 0 V = v(a128)/v(vdd)
* arc s5l_mux4_1 S0 -> X, holding A0=1 A1=0 A2=1 A3=0 S1=1 [state 13 of 16, falling output on a rising S0]
X129 vdd 0 vdd 0 vin vdd a129 vdd 0 s5l_mux4_1
C129 a129 0 0.3p
B129 n129 0 V = v(a129)/v(vdd)
* arc s5l_mux4_1 S0 -> X, holding A0=1 A1=0 A2=1 A3=1 S1=0 [state 14 of 16, falling output on a rising S0]
X130 vdd 0 vdd vdd vin 0 a130 vdd 0 s5l_mux4_1
C130 a130 0 0.3p
B130 n130 0 V = v(a130)/v(vdd)
* arc s5l_mux4_1 S0 -> X, holding A0=1 A1=1 A2=0 A3=1 S1=1 [state 15 of 16, rising output on a rising S0]
X131 vdd vdd 0 vdd vin vdd a131 vdd 0 s5l_mux4_1
C131 a131 0 0.3p
B131 n131 0 V = v(a131)/v(vdd)
* arc s5l_mux4_1 S0 -> X, holding A0=1 A1=1 A2=1 A3=0 S1=1 [state 16 of 16, falling output on a rising S0]
X132 vdd vdd vdd 0 vin vdd a132 vdd 0 s5l_mux4_1
C132 a132 0 0.3p
B132 n132 0 V = v(a132)/v(vdd)
* arc s5l_mux4_1 S1 -> X, holding A0=0 A1=0 A2=0 A3=1 S0=1 [state 1 of 16, rising output on a rising S1]
X133 0 0 0 vdd vdd vin a133 vdd 0 s5l_mux4_1
C133 a133 0 0.3p
B133 n133 0 V = v(a133)/v(vdd)
* arc s5l_mux4_1 S1 -> X, holding A0=0 A1=0 A2=1 A3=0 S0=0 [state 2 of 16, rising output on a rising S1]
X134 0 0 vdd 0 0 vin a134 vdd 0 s5l_mux4_1
C134 a134 0 0.3p
B134 n134 0 V = v(a134)/v(vdd)
* arc s5l_mux4_1 S1 -> X, holding A0=0 A1=0 A2=1 A3=1 S0=0 [state 3 of 16, rising output on a rising S1]
X135 0 0 vdd vdd 0 vin a135 vdd 0 s5l_mux4_1
C135 a135 0 0.3p
B135 n135 0 V = v(a135)/v(vdd)
* arc s5l_mux4_1 S1 -> X, holding A0=0 A1=0 A2=1 A3=1 S0=1 [state 4 of 16, rising output on a rising S1]
X136 0 0 vdd vdd vdd vin a136 vdd 0 s5l_mux4_1
C136 a136 0 0.3p
B136 n136 0 V = v(a136)/v(vdd)
* arc s5l_mux4_1 S1 -> X, holding A0=0 A1=1 A2=0 A3=0 S0=1 [state 5 of 16, falling output on a rising S1]
X137 0 vdd 0 0 vdd vin a137 vdd 0 s5l_mux4_1
C137 a137 0 0.3p
B137 n137 0 V = v(a137)/v(vdd)
* arc s5l_mux4_1 S1 -> X, holding A0=0 A1=1 A2=1 A3=0 S0=0 [state 6 of 16, rising output on a rising S1]
X138 0 vdd vdd 0 0 vin a138 vdd 0 s5l_mux4_1
C138 a138 0 0.3p
B138 n138 0 V = v(a138)/v(vdd)
* arc s5l_mux4_1 S1 -> X, holding A0=0 A1=1 A2=1 A3=0 S0=1 [state 7 of 16, falling output on a rising S1]
X139 0 vdd vdd 0 vdd vin a139 vdd 0 s5l_mux4_1
C139 a139 0 0.3p
B139 n139 0 V = v(a139)/v(vdd)
* arc s5l_mux4_1 S1 -> X, holding A0=0 A1=1 A2=1 A3=1 S0=0 [state 8 of 16, rising output on a rising S1]
X140 0 vdd vdd vdd 0 vin a140 vdd 0 s5l_mux4_1
C140 a140 0 0.3p
B140 n140 0 V = v(a140)/v(vdd)
* arc s5l_mux4_1 S1 -> X, holding A0=1 A1=0 A2=0 A3=0 S0=0 [state 9 of 16, falling output on a rising S1]
X141 vdd 0 0 0 0 vin a141 vdd 0 s5l_mux4_1
C141 a141 0 0.3p
B141 n141 0 V = v(a141)/v(vdd)
* arc s5l_mux4_1 S1 -> X, holding A0=1 A1=0 A2=0 A3=1 S0=0 [state 10 of 16, falling output on a rising S1]
X142 vdd 0 0 vdd 0 vin a142 vdd 0 s5l_mux4_1
C142 a142 0 0.3p
B142 n142 0 V = v(a142)/v(vdd)
* arc s5l_mux4_1 S1 -> X, holding A0=1 A1=0 A2=0 A3=1 S0=1 [state 11 of 16, rising output on a rising S1]
X143 vdd 0 0 vdd vdd vin a143 vdd 0 s5l_mux4_1
C143 a143 0 0.3p
B143 n143 0 V = v(a143)/v(vdd)
* arc s5l_mux4_1 S1 -> X, holding A0=1 A1=0 A2=1 A3=1 S0=1 [state 12 of 16, rising output on a rising S1]
X144 vdd 0 vdd vdd vdd vin a144 vdd 0 s5l_mux4_1
C144 a144 0 0.3p
B144 n144 0 V = v(a144)/v(vdd)
* arc s5l_mux4_1 S1 -> X, holding A0=1 A1=1 A2=0 A3=0 S0=0 [state 13 of 16, falling output on a rising S1]
X145 vdd vdd 0 0 0 vin a145 vdd 0 s5l_mux4_1
C145 a145 0 0.3p
B145 n145 0 V = v(a145)/v(vdd)
* arc s5l_mux4_1 S1 -> X, holding A0=1 A1=1 A2=0 A3=0 S0=1 [state 14 of 16, falling output on a rising S1]
X146 vdd vdd 0 0 vdd vin a146 vdd 0 s5l_mux4_1
C146 a146 0 0.3p
B146 n146 0 V = v(a146)/v(vdd)
* arc s5l_mux4_1 S1 -> X, holding A0=1 A1=1 A2=0 A3=1 S0=0 [state 15 of 16, falling output on a rising S1]
X147 vdd vdd 0 vdd 0 vin a147 vdd 0 s5l_mux4_1
C147 a147 0 0.3p
B147 n147 0 V = v(a147)/v(vdd)
* arc s5l_mux4_1 S1 -> X, holding A0=1 A1=1 A2=1 A3=0 S0=1 [state 16 of 16, falling output on a rising S1]
X148 vdd vdd vdd 0 vdd vin a148 vdd 0 s5l_mux4_1
C148 a148 0 0.3p
B148 n148 0 V = v(a148)/v(vdd)
* arc s5l_nand2_1 A -> Y, holding B=1 [state 1 of 1, falling output on a rising A]
X149 vin vdd a149 vdd 0 s5l_nand2_1
C149 a149 0 0.3p
B149 n149 0 V = v(a149)/v(vdd)
* arc s5l_nand2_1 B -> Y, holding A=1 [state 1 of 1, falling output on a rising B]
X150 vdd vin a150 vdd 0 s5l_nand2_1
C150 a150 0 0.3p
B150 n150 0 V = v(a150)/v(vdd)
* arc s5l_nand2_2 A -> Y, holding B=1 [state 1 of 1, falling output on a rising A]
X151 vin vdd a151 vdd 0 s5l_nand2_2
C151 a151 0 0.3p
B151 n151 0 V = v(a151)/v(vdd)
* arc s5l_nand2_2 B -> Y, holding A=1 [state 1 of 1, falling output on a rising B]
X152 vdd vin a152 vdd 0 s5l_nand2_2
C152 a152 0 0.3p
B152 n152 0 V = v(a152)/v(vdd)
* arc s5l_nand2b_1 A_N -> Y, holding B=1 [state 1 of 1, rising output on a rising A_N]
X153 vin vdd a153 vdd 0 s5l_nand2b_1
C153 a153 0 0.3p
B153 n153 0 V = v(a153)/v(vdd)
* arc s5l_nand2b_1 B -> Y, holding A_N=0 [state 1 of 1, falling output on a rising B]
X154 0 vin a154 vdd 0 s5l_nand2b_1
C154 a154 0 0.3p
B154 n154 0 V = v(a154)/v(vdd)
* arc s5l_nand3_1 A -> Y, holding B=1 C=1 [state 1 of 1, falling output on a rising A]
X155 vin vdd vdd a155 vdd 0 s5l_nand3_1
C155 a155 0 0.3p
B155 n155 0 V = v(a155)/v(vdd)
* arc s5l_nand3_1 B -> Y, holding A=1 C=1 [state 1 of 1, falling output on a rising B]
X156 vdd vin vdd a156 vdd 0 s5l_nand3_1
C156 a156 0 0.3p
B156 n156 0 V = v(a156)/v(vdd)
* arc s5l_nand3_1 C -> Y, holding A=1 B=1 [state 1 of 1, falling output on a rising C]
X157 vdd vdd vin a157 vdd 0 s5l_nand3_1
C157 a157 0 0.3p
B157 n157 0 V = v(a157)/v(vdd)
* arc s5l_nand3b_1 A_N -> Y, holding B=1 C=1 [state 1 of 1, rising output on a rising A_N]
X158 vin vdd vdd a158 vdd 0 s5l_nand3b_1
C158 a158 0 0.3p
B158 n158 0 V = v(a158)/v(vdd)
* arc s5l_nand3b_1 B -> Y, holding A_N=0 C=1 [state 1 of 1, falling output on a rising B]
X159 0 vin vdd a159 vdd 0 s5l_nand3b_1
C159 a159 0 0.3p
B159 n159 0 V = v(a159)/v(vdd)
* arc s5l_nand3b_1 C -> Y, holding A_N=0 B=1 [state 1 of 1, falling output on a rising C]
X160 0 vdd vin a160 vdd 0 s5l_nand3b_1
C160 a160 0 0.3p
B160 n160 0 V = v(a160)/v(vdd)
* arc s5l_nand4_1 A -> Y, holding B=1 C=1 D=1 [state 1 of 1, falling output on a rising A]
X161 vin vdd vdd vdd a161 vdd 0 s5l_nand4_1
C161 a161 0 0.3p
B161 n161 0 V = v(a161)/v(vdd)
* arc s5l_nand4_1 B -> Y, holding A=1 C=1 D=1 [state 1 of 1, falling output on a rising B]
X162 vdd vin vdd vdd a162 vdd 0 s5l_nand4_1
C162 a162 0 0.3p
B162 n162 0 V = v(a162)/v(vdd)
* arc s5l_nand4_1 C -> Y, holding A=1 B=1 D=1 [state 1 of 1, falling output on a rising C]
X163 vdd vdd vin vdd a163 vdd 0 s5l_nand4_1
C163 a163 0 0.3p
B163 n163 0 V = v(a163)/v(vdd)
* arc s5l_nand4_1 D -> Y, holding A=1 B=1 C=1 [state 1 of 1, falling output on a rising D]
X164 vdd vdd vdd vin a164 vdd 0 s5l_nand4_1
C164 a164 0 0.3p
B164 n164 0 V = v(a164)/v(vdd)
* arc s5l_nor2_1 A -> Y, holding B=0 [state 1 of 1, falling output on a rising A]
X165 vin 0 a165 vdd 0 s5l_nor2_1
C165 a165 0 0.3p
B165 n165 0 V = v(a165)/v(vdd)
* arc s5l_nor2_1 B -> Y, holding A=0 [state 1 of 1, falling output on a rising B]
X166 0 vin a166 vdd 0 s5l_nor2_1
C166 a166 0 0.3p
B166 n166 0 V = v(a166)/v(vdd)
* arc s5l_nor2_2 A -> Y, holding B=0 [state 1 of 1, falling output on a rising A]
X167 vin 0 a167 vdd 0 s5l_nor2_2
C167 a167 0 0.3p
B167 n167 0 V = v(a167)/v(vdd)
* arc s5l_nor2_2 B -> Y, holding A=0 [state 1 of 1, falling output on a rising B]
X168 0 vin a168 vdd 0 s5l_nor2_2
C168 a168 0 0.3p
B168 n168 0 V = v(a168)/v(vdd)
* arc s5l_nor2b_1 A -> Y, holding B_N=1 [state 1 of 1, falling output on a rising A]
X169 vin vdd a169 vdd 0 s5l_nor2b_1
C169 a169 0 0.3p
B169 n169 0 V = v(a169)/v(vdd)
* arc s5l_nor2b_1 B_N -> Y, holding A=0 [state 1 of 1, rising output on a rising B_N]
X170 0 vin a170 vdd 0 s5l_nor2b_1
C170 a170 0 0.3p
B170 n170 0 V = v(a170)/v(vdd)
* arc s5l_nor3_1 A -> Y, holding B=0 C=0 [state 1 of 1, falling output on a rising A]
X171 vin 0 0 a171 vdd 0 s5l_nor3_1
C171 a171 0 0.3p
B171 n171 0 V = v(a171)/v(vdd)
* arc s5l_nor3_1 B -> Y, holding A=0 C=0 [state 1 of 1, falling output on a rising B]
X172 0 vin 0 a172 vdd 0 s5l_nor3_1
C172 a172 0 0.3p
B172 n172 0 V = v(a172)/v(vdd)
* arc s5l_nor3_1 C -> Y, holding A=0 B=0 [state 1 of 1, falling output on a rising C]
X173 0 0 vin a173 vdd 0 s5l_nor3_1
C173 a173 0 0.3p
B173 n173 0 V = v(a173)/v(vdd)
* arc s5l_nor3_2 A -> Y, holding B=0 C=0 [state 1 of 1, falling output on a rising A]
X174 vin 0 0 a174 vdd 0 s5l_nor3_2
C174 a174 0 0.3p
B174 n174 0 V = v(a174)/v(vdd)
* arc s5l_nor3_2 B -> Y, holding A=0 C=0 [state 1 of 1, falling output on a rising B]
X175 0 vin 0 a175 vdd 0 s5l_nor3_2
C175 a175 0 0.3p
B175 n175 0 V = v(a175)/v(vdd)
* arc s5l_nor3_2 C -> Y, holding A=0 B=0 [state 1 of 1, falling output on a rising C]
X176 0 0 vin a176 vdd 0 s5l_nor3_2
C176 a176 0 0.3p
B176 n176 0 V = v(a176)/v(vdd)
* arc s5l_nor4_1 A -> Y, holding B=0 C=0 D=0 [state 1 of 1, falling output on a rising A]
X177 vin 0 0 0 a177 vdd 0 s5l_nor4_1
C177 a177 0 0.3p
B177 n177 0 V = v(a177)/v(vdd)
* arc s5l_nor4_1 B -> Y, holding A=0 C=0 D=0 [state 1 of 1, falling output on a rising B]
X178 0 vin 0 0 a178 vdd 0 s5l_nor4_1
C178 a178 0 0.3p
B178 n178 0 V = v(a178)/v(vdd)
* arc s5l_nor4_1 C -> Y, holding A=0 B=0 D=0 [state 1 of 1, falling output on a rising C]
X179 0 0 vin 0 a179 vdd 0 s5l_nor4_1
C179 a179 0 0.3p
B179 n179 0 V = v(a179)/v(vdd)
* arc s5l_nor4_1 D -> Y, holding A=0 B=0 C=0 [state 1 of 1, falling output on a rising D]
X180 0 0 0 vin a180 vdd 0 s5l_nor4_1
C180 a180 0 0.3p
B180 n180 0 V = v(a180)/v(vdd)
* arc s5l_o21ai_1 A1 -> Y, holding A2=0 B1=1 [state 1 of 1, falling output on a rising A1]
X181 vin 0 vdd a181 vdd 0 s5l_o21ai_1
C181 a181 0 0.3p
B181 n181 0 V = v(a181)/v(vdd)
* arc s5l_o21ai_1 A2 -> Y, holding A1=0 B1=1 [state 1 of 1, falling output on a rising A2]
X182 0 vin vdd a182 vdd 0 s5l_o21ai_1
C182 a182 0 0.3p
B182 n182 0 V = v(a182)/v(vdd)
* arc s5l_o21ai_1 B1 -> Y, holding A1=0 A2=1 [state 1 of 3, falling output on a rising B1]
X183 0 vdd vin a183 vdd 0 s5l_o21ai_1
C183 a183 0 0.3p
B183 n183 0 V = v(a183)/v(vdd)
* arc s5l_o21ai_1 B1 -> Y, holding A1=1 A2=0 [state 2 of 3, falling output on a rising B1]
X184 vdd 0 vin a184 vdd 0 s5l_o21ai_1
C184 a184 0 0.3p
B184 n184 0 V = v(a184)/v(vdd)
* arc s5l_o21ai_1 B1 -> Y, holding A1=1 A2=1 [state 3 of 3, falling output on a rising B1]
X185 vdd vdd vin a185 vdd 0 s5l_o21ai_1
C185 a185 0 0.3p
B185 n185 0 V = v(a185)/v(vdd)
* arc s5l_or2_1 A -> X, holding B=0 [state 1 of 1, rising output on a rising A]
X186 vin 0 a186 vdd 0 s5l_or2_1
C186 a186 0 0.3p
B186 n186 0 V = v(a186)/v(vdd)
* arc s5l_or2_1 B -> X, holding A=0 [state 1 of 1, rising output on a rising B]
X187 0 vin a187 vdd 0 s5l_or2_1
C187 a187 0 0.3p
B187 n187 0 V = v(a187)/v(vdd)
* arc s5l_or2_2 A -> X, holding B=0 [state 1 of 1, rising output on a rising A]
X188 vin 0 a188 vdd 0 s5l_or2_2
C188 a188 0 0.3p
B188 n188 0 V = v(a188)/v(vdd)
* arc s5l_or2_2 B -> X, holding A=0 [state 1 of 1, rising output on a rising B]
X189 0 vin a189 vdd 0 s5l_or2_2
C189 a189 0 0.3p
B189 n189 0 V = v(a189)/v(vdd)
* arc s5l_or3_1 A -> X, holding B=0 C=0 [state 1 of 1, rising output on a rising A]
X190 vin 0 0 a190 vdd 0 s5l_or3_1
C190 a190 0 0.3p
B190 n190 0 V = v(a190)/v(vdd)
* arc s5l_or3_1 B -> X, holding A=0 C=0 [state 1 of 1, rising output on a rising B]
X191 0 vin 0 a191 vdd 0 s5l_or3_1
C191 a191 0 0.3p
B191 n191 0 V = v(a191)/v(vdd)
* arc s5l_or3_1 C -> X, holding A=0 B=0 [state 1 of 1, rising output on a rising C]
X192 0 0 vin a192 vdd 0 s5l_or3_1
C192 a192 0 0.3p
B192 n192 0 V = v(a192)/v(vdd)
* arc s5l_or3_2 A -> X, holding B=0 C=0 [state 1 of 1, rising output on a rising A]
X193 vin 0 0 a193 vdd 0 s5l_or3_2
C193 a193 0 0.3p
B193 n193 0 V = v(a193)/v(vdd)
* arc s5l_or3_2 B -> X, holding A=0 C=0 [state 1 of 1, rising output on a rising B]
X194 0 vin 0 a194 vdd 0 s5l_or3_2
C194 a194 0 0.3p
B194 n194 0 V = v(a194)/v(vdd)
* arc s5l_or3_2 C -> X, holding A=0 B=0 [state 1 of 1, rising output on a rising C]
X195 0 0 vin a195 vdd 0 s5l_or3_2
C195 a195 0 0.3p
B195 n195 0 V = v(a195)/v(vdd)
* arc s5l_or4_1 A -> X, holding B=0 C=0 D=0 [state 1 of 1, rising output on a rising A]
X196 vin 0 0 0 a196 vdd 0 s5l_or4_1
C196 a196 0 0.3p
B196 n196 0 V = v(a196)/v(vdd)
* arc s5l_or4_1 B -> X, holding A=0 C=0 D=0 [state 1 of 1, rising output on a rising B]
X197 0 vin 0 0 a197 vdd 0 s5l_or4_1
C197 a197 0 0.3p
B197 n197 0 V = v(a197)/v(vdd)
* arc s5l_or4_1 C -> X, holding A=0 B=0 D=0 [state 1 of 1, rising output on a rising C]
X198 0 0 vin 0 a198 vdd 0 s5l_or4_1
C198 a198 0 0.3p
B198 n198 0 V = v(a198)/v(vdd)
* arc s5l_or4_1 D -> X, holding A=0 B=0 C=0 [state 1 of 1, rising output on a rising D]
X199 0 0 0 vin a199 vdd 0 s5l_or4_1
C199 a199 0 0.3p
B199 n199 0 V = v(a199)/v(vdd)
* arc s5l_xnor2_1 A -> Y, holding B=0 [state 1 of 2, falling output on a rising A]
X200 vin 0 a200 vdd 0 s5l_xnor2_1
C200 a200 0 0.3p
B200 n200 0 V = v(a200)/v(vdd)
* arc s5l_xnor2_1 A -> Y, holding B=1 [state 2 of 2, rising output on a rising A]
X201 vin vdd a201 vdd 0 s5l_xnor2_1
C201 a201 0 0.3p
B201 n201 0 V = v(a201)/v(vdd)
* arc s5l_xnor2_1 B -> Y, holding A=0 [state 1 of 2, falling output on a rising B]
X202 0 vin a202 vdd 0 s5l_xnor2_1
C202 a202 0 0.3p
B202 n202 0 V = v(a202)/v(vdd)
* arc s5l_xnor2_1 B -> Y, holding A=1 [state 2 of 2, rising output on a rising B]
X203 vdd vin a203 vdd 0 s5l_xnor2_1
C203 a203 0 0.3p
B203 n203 0 V = v(a203)/v(vdd)
* arc s5l_xor2_1 A -> X, holding B=0 [state 1 of 2, rising output on a rising A]
X204 vin 0 a204 vdd 0 s5l_xor2_1
C204 a204 0 0.3p
B204 n204 0 V = v(a204)/v(vdd)
* arc s5l_xor2_1 A -> X, holding B=1 [state 2 of 2, falling output on a rising A]
X205 vin vdd a205 vdd 0 s5l_xor2_1
C205 a205 0 0.3p
B205 n205 0 V = v(a205)/v(vdd)
* arc s5l_xor2_1 B -> X, holding A=0 [state 1 of 2, rising output on a rising B]
X206 0 vin a206 vdd 0 s5l_xor2_1
C206 a206 0 0.3p
B206 n206 0 V = v(a206)/v(vdd)
* arc s5l_xor2_1 B -> X, holding A=1 [state 2 of 2, falling output on a rising B]
X207 vdd vin a207 vdd 0 s5l_xor2_1
C207 a207 0 0.3p
B207 n207 0 V = v(a207)/v(vdd)
