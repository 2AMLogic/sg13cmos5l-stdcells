* s5l_nor3_2 -- generated by design/gen_netlists.py from design/cells.json; do not edit.
* family nor3, drive 2, sg13_lv devices, L=130n, supply 1.20 V.
* Y = !(A+B+C)
.subckt s5l_nor3_2 A B C Y VDD VSS
XMN0 Y A VSS VSS sg13_lv_nmos w=1480n l=130n ng=2 m=1
XMN1 Y B VSS VSS sg13_lv_nmos w=1480n l=130n ng=2 m=1
XMN2 Y C VSS VSS sg13_lv_nmos w=1480n l=130n ng=2 m=1
XMP0 Y A n1 VDD sg13_lv_pmos w=6720n l=130n ng=6 m=1
XMP1 n1 B n2 VDD sg13_lv_pmos w=6720n l=130n ng=6 m=1
XMP2 n2 C VDD VDD sg13_lv_pmos w=6720n l=130n ng=6 m=1
.ends s5l_nor3_2
