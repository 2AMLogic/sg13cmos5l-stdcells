* s5l_and2_2 -- generated by design/gen_netlists.py from design/cells.json; do not edit.
* family and2, drive 2, L=130n, supply 1.20 V.
* X = (A*B)
.subckt s5l_and2_2 A B X VDD VSS
XMN0 X_i A n1 VSS sg13_lv_nmos w=1480n l=130n ng=2 m=1
XMN1 n1 B VSS VSS sg13_lv_nmos w=1480n l=130n ng=2 m=1
XMP0 X_i A VDD VDD sg13_lv_pmos w=1120n l=130n ng=1 m=1
XMP1 X_i B VDD VDD sg13_lv_pmos w=1120n l=130n ng=1 m=1
XMN2 X X_i VSS VSS sg13_lv_nmos w=1480n l=130n ng=2 m=1
XMP2 X X_i VDD VDD sg13_lv_pmos w=2240n l=130n ng=2 m=1
.ends s5l_and2_2
