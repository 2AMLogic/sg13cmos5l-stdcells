* s5l_nor2b_1 -- generated by design/gen_netlists.py from design/cells.json; do not edit.
* family nor2b, drive 1, sg13_lv devices, L=130n, supply 1.20 V.
* Y = !(A+!B_N)
.subckt s5l_nor2b_1 A B_N Y VDD VSS
XMN0 Y A VSS VSS sg13_lv_nmos w=740n l=130n ng=1 m=1
XMN1 B_N_b B_N VSS VSS sg13_lv_nmos w=740n l=130n ng=1 m=1
XMP0 B_N_b B_N VDD VDD sg13_lv_pmos w=1120n l=130n ng=1 m=1
XMN2 Y B_N_b VSS VSS sg13_lv_nmos w=740n l=130n ng=1 m=1
XMP1 Y A n1 VDD sg13_lv_pmos w=2240n l=130n ng=2 m=1
XMP2 n1 B_N_b VDD VDD sg13_lv_pmos w=2240n l=130n ng=2 m=1
.ends s5l_nor2b_1
