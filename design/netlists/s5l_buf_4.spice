* s5l_buf_4 -- generated by design/gen_netlists.py from design/cells.json; do not edit.
* family buf, drive 4, sg13_lv devices, L=130n, supply 1.20 V.
* X = A
.subckt s5l_buf_4 A X VDD VSS
XMN0 X_i A VSS VSS sg13_lv_nmos w=1480n l=130n ng=2 m=1
XMP0 X_i A VDD VDD sg13_lv_pmos w=2240n l=130n ng=2 m=1
XMN1 X X_i VSS VSS sg13_lv_nmos w=2960n l=130n ng=4 m=1
XMP1 X X_i VDD VDD sg13_lv_pmos w=4480n l=130n ng=4 m=1
.ends s5l_buf_4
