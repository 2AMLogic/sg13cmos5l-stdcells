* s5l_nand2_2 -- generated by design/gen_netlists.py from design/cells.json; do not edit.
* family nand2, drive 2, sg13_lv devices, L=130n, supply 1.20 V.
* Y = !(A*B)
.subckt s5l_nand2_2 A B Y VDD VSS
XMN0 Y A n1 VSS sg13_lv_nmos w=2960n l=130n ng=4 m=1
XMN1 n1 B VSS VSS sg13_lv_nmos w=2960n l=130n ng=4 m=1
XMP0 Y A VDD VDD sg13_lv_pmos w=2240n l=130n ng=2 m=1
XMP1 Y B VDD VDD sg13_lv_pmos w=2240n l=130n ng=2 m=1
.ends s5l_nand2_2
