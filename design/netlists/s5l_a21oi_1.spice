* s5l_a21oi_1 -- generated by design/gen_netlists.py from design/cells.json; do not edit.
* family a21oi, drive 1, sg13_lv devices, L=130n, supply 1.20 V.
* Y = !((A1*A2)+B1)
.subckt s5l_a21oi_1 A1 A2 B1 Y VDD VSS
XMN0 Y A1 n1 VSS sg13_lv_nmos w=1480n l=130n ng=2 m=1
XMN1 n1 A2 VSS VSS sg13_lv_nmos w=1480n l=130n ng=2 m=1
XMN2 Y B1 VSS VSS sg13_lv_nmos w=740n l=130n ng=1 m=1
XMP0 Y A1 n2 VDD sg13_lv_pmos w=2240n l=130n ng=2 m=1
XMP1 Y A2 n2 VDD sg13_lv_pmos w=2240n l=130n ng=2 m=1
XMP2 n2 B1 VDD VDD sg13_lv_pmos w=2240n l=130n ng=2 m=1
.ends s5l_a21oi_1
