* s5l_nand4_1 -- generated by design/gen_netlists.py from design/cells.json; do not edit.
* family nand4, drive 1, L=130n, supply 1.20 V.
* Y = !(A*B*C*D)
.subckt s5l_nand4_1 A B C D Y VDD VSS
XMN0 Y A n1 VSS sg13_lv_nmos w=2960n l=130n ng=4 m=1
XMN1 n1 B n2 VSS sg13_lv_nmos w=2960n l=130n ng=4 m=1
XMN2 n2 C n3 VSS sg13_lv_nmos w=2960n l=130n ng=4 m=1
XMN3 n3 D VSS VSS sg13_lv_nmos w=2960n l=130n ng=4 m=1
XMP0 Y A VDD VDD sg13_lv_pmos w=1120n l=130n ng=1 m=1
XMP1 Y B VDD VDD sg13_lv_pmos w=1120n l=130n ng=1 m=1
XMP2 Y C VDD VDD sg13_lv_pmos w=1120n l=130n ng=1 m=1
XMP3 Y D VDD VDD sg13_lv_pmos w=1120n l=130n ng=1 m=1
.ends s5l_nand4_1
