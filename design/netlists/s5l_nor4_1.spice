* s5l_nor4_1 -- generated by design/gen_netlists.py from design/cells.json; do not edit.
* family nor4, drive 1, sg13_lv devices, L=130n, supply 1.20 V.
* Y = !(A+B+C+D)
.subckt s5l_nor4_1 A B C D Y VDD VSS
XMN0 Y A VSS VSS sg13_lv_nmos w=740n l=130n ng=1 m=1
XMN1 Y B VSS VSS sg13_lv_nmos w=740n l=130n ng=1 m=1
XMN2 Y C VSS VSS sg13_lv_nmos w=740n l=130n ng=1 m=1
XMN3 Y D VSS VSS sg13_lv_nmos w=740n l=130n ng=1 m=1
XMP0 Y A n1 VDD sg13_lv_pmos w=4480n l=130n ng=4 m=1
XMP1 n1 B n2 VDD sg13_lv_pmos w=4480n l=130n ng=4 m=1
XMP2 n2 C n3 VDD sg13_lv_pmos w=4480n l=130n ng=4 m=1
XMP3 n3 D VDD VDD sg13_lv_pmos w=4480n l=130n ng=4 m=1
.ends s5l_nor4_1
