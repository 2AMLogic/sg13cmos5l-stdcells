* s5l_and4_1 -- generated by design/gen_netlists.py from design/cells.json; do not edit.
* family and4, drive 1, sg13_lv devices, L=130n, supply 1.20 V.
* X = (A*B*C*D)
.subckt s5l_and4_1 A B C D X VDD VSS
XMN0 X_i A n1 VSS sg13_lv_nmos w=2960n l=130n ng=4 m=1
XMN1 n1 B n2 VSS sg13_lv_nmos w=2960n l=130n ng=4 m=1
XMN2 n2 C n3 VSS sg13_lv_nmos w=2960n l=130n ng=4 m=1
XMN3 n3 D VSS VSS sg13_lv_nmos w=2960n l=130n ng=4 m=1
XMP0 X_i A VDD VDD sg13_lv_pmos w=1120n l=130n ng=1 m=1
XMP1 X_i B VDD VDD sg13_lv_pmos w=1120n l=130n ng=1 m=1
XMP2 X_i C VDD VDD sg13_lv_pmos w=1120n l=130n ng=1 m=1
XMP3 X_i D VDD VDD sg13_lv_pmos w=1120n l=130n ng=1 m=1
XMN4 X X_i VSS VSS sg13_lv_nmos w=740n l=130n ng=1 m=1
XMP4 X X_i VDD VDD sg13_lv_pmos w=1120n l=130n ng=1 m=1
.ends s5l_and4_1
