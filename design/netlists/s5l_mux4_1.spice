* s5l_mux4_1 -- generated by design/gen_netlists.py from design/cells.json; do not edit.
* family mux4, drive 1, sg13_lv devices, L=130n, supply 1.20 V.
* X = (A0*(!S0*!S1))+(A1*(S0*!S1))+(A2*(!S0*S1))+(A3*(S0*S1))
.subckt s5l_mux4_1 A0 A1 A2 A3 S0 S1 X VDD VSS
XMN0 X_i A0 n1 VSS sg13_lv_nmos w=2220n l=130n ng=3 m=1
XMN1 S0_b S0 VSS VSS sg13_lv_nmos w=740n l=130n ng=1 m=1
XMP0 S0_b S0 VDD VDD sg13_lv_pmos w=1120n l=130n ng=1 m=1
XMN2 n1 S0_b n2 VSS sg13_lv_nmos w=2220n l=130n ng=3 m=1
XMN3 S1_b S1 VSS VSS sg13_lv_nmos w=740n l=130n ng=1 m=1
XMP1 S1_b S1 VDD VDD sg13_lv_pmos w=1120n l=130n ng=1 m=1
XMN4 n2 S1_b VSS VSS sg13_lv_nmos w=2220n l=130n ng=3 m=1
XMN5 X_i A1 n3 VSS sg13_lv_nmos w=2220n l=130n ng=3 m=1
XMN6 n3 S0 n4 VSS sg13_lv_nmos w=2220n l=130n ng=3 m=1
XMN7 n4 S1_b VSS VSS sg13_lv_nmos w=2220n l=130n ng=3 m=1
XMN8 X_i A2 n5 VSS sg13_lv_nmos w=2220n l=130n ng=3 m=1
XMN9 n5 S0_b n6 VSS sg13_lv_nmos w=2220n l=130n ng=3 m=1
XMN10 n6 S1 VSS VSS sg13_lv_nmos w=2220n l=130n ng=3 m=1
XMN11 X_i A3 n7 VSS sg13_lv_nmos w=2220n l=130n ng=3 m=1
XMN12 n7 S0 n8 VSS sg13_lv_nmos w=2220n l=130n ng=3 m=1
XMN13 n8 S1 VSS VSS sg13_lv_nmos w=2220n l=130n ng=3 m=1
XMP2 X_i A0 n9 VDD sg13_lv_pmos w=4480n l=130n ng=4 m=1
XMP3 X_i S0_b n9 VDD sg13_lv_pmos w=4480n l=130n ng=4 m=1
XMP4 X_i S1_b n9 VDD sg13_lv_pmos w=4480n l=130n ng=4 m=1
XMP5 n9 A1 n10 VDD sg13_lv_pmos w=4480n l=130n ng=4 m=1
XMP6 n9 S0 n10 VDD sg13_lv_pmos w=4480n l=130n ng=4 m=1
XMP7 n9 S1_b n10 VDD sg13_lv_pmos w=4480n l=130n ng=4 m=1
XMP8 n10 A2 n11 VDD sg13_lv_pmos w=4480n l=130n ng=4 m=1
XMP9 n10 S0_b n11 VDD sg13_lv_pmos w=4480n l=130n ng=4 m=1
XMP10 n10 S1 n11 VDD sg13_lv_pmos w=4480n l=130n ng=4 m=1
XMP11 n11 A3 VDD VDD sg13_lv_pmos w=4480n l=130n ng=4 m=1
XMP12 n11 S0 VDD VDD sg13_lv_pmos w=4480n l=130n ng=4 m=1
XMP13 n11 S1 VDD VDD sg13_lv_pmos w=4480n l=130n ng=4 m=1
XMN14 X X_i VSS VSS sg13_lv_nmos w=740n l=130n ng=1 m=1
XMP14 X X_i VDD VDD sg13_lv_pmos w=1120n l=130n ng=1 m=1
.ends s5l_mux4_1
