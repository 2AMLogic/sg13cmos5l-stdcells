* s5l_or4_1 -- generated by design/gen_netlists.py from design/cells.json; do not edit.
* family or4, drive 1, L=130n, supply 1.20 V.
* X = (A+B+C+D)
.subckt s5l_or4_1 A B C D X VDD VSS
XMN0 X_i A VSS VSS sg13_lv_nmos w=740n l=130n ng=1 m=1
XMN1 X_i B VSS VSS sg13_lv_nmos w=740n l=130n ng=1 m=1
XMN2 X_i C VSS VSS sg13_lv_nmos w=740n l=130n ng=1 m=1
XMN3 X_i D VSS VSS sg13_lv_nmos w=740n l=130n ng=1 m=1
XMP0 X_i A n1 VDD sg13_lv_pmos w=4480n l=130n ng=4 m=1
XMP1 n1 B n2 VDD sg13_lv_pmos w=4480n l=130n ng=4 m=1
XMP2 n2 C n3 VDD sg13_lv_pmos w=4480n l=130n ng=4 m=1
XMP3 n3 D VDD VDD sg13_lv_pmos w=4480n l=130n ng=4 m=1
XMN4 X X_i VSS VSS sg13_lv_nmos w=740n l=130n ng=1 m=1
XMP4 X X_i VDD VDD sg13_lv_pmos w=1120n l=130n ng=1 m=1
.ends s5l_or4_1
