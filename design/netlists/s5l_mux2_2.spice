* s5l_mux2_2 -- generated by design/gen_netlists.py from design/cells.json; do not edit.
* family mux2, drive 2, sg13_lv devices, L=130n, supply 1.20 V.
* X = (!S*A0)+(S*A1)
.subckt s5l_mux2_2 A0 A1 S X VDD VSS
XMN0 S_b S VSS VSS sg13_lv_nmos w=740n l=130n ng=1 m=1
XMP0 S_b S VDD VDD sg13_lv_pmos w=1120n l=130n ng=1 m=1
XMN1 X_i S_b n1 VSS sg13_lv_nmos w=1480n l=130n ng=2 m=1
XMN2 n1 A0 VSS VSS sg13_lv_nmos w=1480n l=130n ng=2 m=1
XMN3 X_i S n2 VSS sg13_lv_nmos w=1480n l=130n ng=2 m=1
XMN4 n2 A1 VSS VSS sg13_lv_nmos w=1480n l=130n ng=2 m=1
XMP1 X_i S_b n3 VDD sg13_lv_pmos w=2240n l=130n ng=2 m=1
XMP2 X_i A0 n3 VDD sg13_lv_pmos w=2240n l=130n ng=2 m=1
XMP3 n3 S VDD VDD sg13_lv_pmos w=2240n l=130n ng=2 m=1
XMP4 n3 A1 VDD VDD sg13_lv_pmos w=2240n l=130n ng=2 m=1
XMN5 X X_i VSS VSS sg13_lv_nmos w=1480n l=130n ng=2 m=1
XMP5 X X_i VDD VDD sg13_lv_pmos w=2240n l=130n ng=2 m=1
.ends s5l_mux2_2
