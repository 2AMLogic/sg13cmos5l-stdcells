* s5l_xor2_1 -- generated by design/gen_netlists.py from design/cells.json; do not edit.
* family xor2, drive 1, sg13_lv devices, L=130n, supply 1.20 V.
* X = (A^B)
.subckt s5l_xor2_1 A B X VDD VSS
XMN0 X_i A n1 VSS sg13_lv_nmos w=1480n l=130n ng=2 m=1
XMN1 B_b B VSS VSS sg13_lv_nmos w=740n l=130n ng=1 m=1
XMP0 B_b B VDD VDD sg13_lv_pmos w=1120n l=130n ng=1 m=1
XMN2 n1 B_b VSS VSS sg13_lv_nmos w=1480n l=130n ng=2 m=1
XMN3 A_b A VSS VSS sg13_lv_nmos w=740n l=130n ng=1 m=1
XMP1 A_b A VDD VDD sg13_lv_pmos w=1120n l=130n ng=1 m=1
XMN4 X_i A_b n2 VSS sg13_lv_nmos w=1480n l=130n ng=2 m=1
XMN5 n2 B VSS VSS sg13_lv_nmos w=1480n l=130n ng=2 m=1
XMP2 X_i A n3 VDD sg13_lv_pmos w=2240n l=130n ng=2 m=1
XMP3 X_i B_b n3 VDD sg13_lv_pmos w=2240n l=130n ng=2 m=1
XMP4 n3 A_b VDD VDD sg13_lv_pmos w=2240n l=130n ng=2 m=1
XMP5 n3 B VDD VDD sg13_lv_pmos w=2240n l=130n ng=2 m=1
XMN6 X X_i VSS VSS sg13_lv_nmos w=740n l=130n ng=1 m=1
XMP6 X X_i VDD VDD sg13_lv_pmos w=1120n l=130n ng=1 m=1
.ends s5l_xor2_1
