* s5l_inv_2 -- generated by design/gen_netlists.py from design/cells.json; do not edit.
* family inv, drive 2, sg13_lv devices, L=130n, supply 1.20 V.
* Y = !(A)
.subckt s5l_inv_2 A Y VDD VSS
XMN0 Y A VSS VSS sg13_lv_nmos w=1480n l=130n ng=2 m=1
XMP0 Y A VDD VDD sg13_lv_pmos w=2240n l=130n ng=2 m=1
.ends s5l_inv_2
