* s5l_nor2_2 -- generated by design/gen_netlists.py from design/cells.json; do not edit.
* family nor2, drive 2, sg13_lv devices, L=130n, supply 1.20 V.
* Y = !(A+B)
.subckt s5l_nor2_2 A B Y VDD VSS
XMN0 Y A VSS VSS sg13_lv_nmos w=1480n l=130n ng=2 m=1
XMN1 Y B VSS VSS sg13_lv_nmos w=1480n l=130n ng=2 m=1
XMP0 Y A n1 VDD sg13_lv_pmos w=4480n l=130n ng=4 m=1
XMP1 n1 B VDD VDD sg13_lv_pmos w=4480n l=130n ng=4 m=1
.ends s5l_nor2_2
