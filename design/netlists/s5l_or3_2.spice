* s5l_or3_2 -- generated by design/gen_netlists.py from design/cells.json; do not edit.
* family or3, drive 2, sg13_lv devices, L=130n, supply 1.20 V.
* X = (A+B+C)
.subckt s5l_or3_2 A B C X VDD VSS
XMN0 X_i A VSS VSS sg13_lv_nmos w=740n l=130n ng=1 m=1
XMN1 X_i B VSS VSS sg13_lv_nmos w=740n l=130n ng=1 m=1
XMN2 X_i C VSS VSS sg13_lv_nmos w=740n l=130n ng=1 m=1
XMP0 X_i A n1 VDD sg13_lv_pmos w=3360n l=130n ng=3 m=1
XMP1 n1 B n2 VDD sg13_lv_pmos w=3360n l=130n ng=3 m=1
XMP2 n2 C VDD VDD sg13_lv_pmos w=3360n l=130n ng=3 m=1
XMN3 X X_i VSS VSS sg13_lv_nmos w=1480n l=130n ng=2 m=1
XMP3 X X_i VDD VDD sg13_lv_pmos w=2240n l=130n ng=2 m=1
.ends s5l_or3_2
