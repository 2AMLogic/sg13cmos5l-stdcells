* s5l_a22oi_1 -- generated by design/gen_netlists.py from design/cells.json; do not edit.
* family a22oi, drive 1, sg13_lv devices, L=130n, supply 1.20 V.
* Y = !((A1*A2)+(B1*B2))
.subckt s5l_a22oi_1 A1 A2 B1 B2 Y VDD VSS
XMN0 Y A1 n1 VSS sg13_lv_nmos w=1480n l=130n ng=2 m=1
XMN1 n1 A2 VSS VSS sg13_lv_nmos w=1480n l=130n ng=2 m=1
XMN2 Y B1 n2 VSS sg13_lv_nmos w=1480n l=130n ng=2 m=1
XMN3 n2 B2 VSS VSS sg13_lv_nmos w=1480n l=130n ng=2 m=1
XMP0 Y A1 n3 VDD sg13_lv_pmos w=2240n l=130n ng=2 m=1
XMP1 Y A2 n3 VDD sg13_lv_pmos w=2240n l=130n ng=2 m=1
XMP2 n3 B1 VDD VDD sg13_lv_pmos w=2240n l=130n ng=2 m=1
XMP3 n3 B2 VDD VDD sg13_lv_pmos w=2240n l=130n ng=2 m=1
.ends s5l_a22oi_1
