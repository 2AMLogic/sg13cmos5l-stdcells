* s5l_and3_1 -- generated by design/gen_netlists.py from design/cells.json; do not edit.
* family and3, drive 1, sg13_lv devices, L=130n, supply 1.20 V.
* X = (A*B*C)
.subckt s5l_and3_1 A B C X VDD VSS
XMN0 X_i A n1 VSS sg13_lv_nmos w=2220n l=130n ng=3 m=1
XMN1 n1 B n2 VSS sg13_lv_nmos w=2220n l=130n ng=3 m=1
XMN2 n2 C VSS VSS sg13_lv_nmos w=2220n l=130n ng=3 m=1
XMP0 X_i A VDD VDD sg13_lv_pmos w=1120n l=130n ng=1 m=1
XMP1 X_i B VDD VDD sg13_lv_pmos w=1120n l=130n ng=1 m=1
XMP2 X_i C VDD VDD sg13_lv_pmos w=1120n l=130n ng=1 m=1
XMN3 X X_i VSS VSS sg13_lv_nmos w=740n l=130n ng=1 m=1
XMP3 X X_i VDD VDD sg13_lv_pmos w=1120n l=130n ng=1 m=1
.ends s5l_and3_1
