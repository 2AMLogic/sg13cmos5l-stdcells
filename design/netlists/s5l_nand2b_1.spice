* s5l_nand2b_1 -- generated by design/gen_netlists.py from design/cells.json; do not edit.
* family nand2b, drive 1, sg13_lv devices, L=130n, supply 1.20 V.
* Y = !(!A_N*B)
.subckt s5l_nand2b_1 A_N B Y VDD VSS
XMN0 A_N_b A_N VSS VSS sg13_lv_nmos w=740n l=130n ng=1 m=1
XMP0 A_N_b A_N VDD VDD sg13_lv_pmos w=1120n l=130n ng=1 m=1
XMN1 Y A_N_b n1 VSS sg13_lv_nmos w=1480n l=130n ng=2 m=1
XMN2 n1 B VSS VSS sg13_lv_nmos w=1480n l=130n ng=2 m=1
XMP1 Y A_N_b VDD VDD sg13_lv_pmos w=1120n l=130n ng=1 m=1
XMP2 Y B VDD VDD sg13_lv_pmos w=1120n l=130n ng=1 m=1
.ends s5l_nand2b_1
