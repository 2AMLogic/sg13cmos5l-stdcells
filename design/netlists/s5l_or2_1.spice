* s5l_or2_1 -- generated by design/gen_netlists.py from design/cells.json; do not edit.
* family or2, drive 1, sg13_lv devices, L=130n, supply 1.20 V.
* X = (A+B)
.subckt s5l_or2_1 A B X VDD VSS
XMN0 X_i A VSS VSS sg13_lv_nmos w=740n l=130n ng=1 m=1
XMN1 X_i B VSS VSS sg13_lv_nmos w=740n l=130n ng=1 m=1
XMP0 X_i A n1 VDD sg13_lv_pmos w=2240n l=130n ng=2 m=1
XMP1 n1 B VDD VDD sg13_lv_pmos w=2240n l=130n ng=2 m=1
XMN2 X X_i VSS VSS sg13_lv_nmos w=740n l=130n ng=1 m=1
XMP2 X X_i VDD VDD sg13_lv_pmos w=1120n l=130n ng=1 m=1
.ends s5l_or2_1
